.include TSMC_180nm.txt
.param SUPPLY=1.8
.global gnd vdd
.param LAMBDA=0.09u
.param width_N=1.8u
.param width_P=2*width_N
.param L=2*LAMBDA

Va a gnd PULSE(0 1.8   0n 0n 0n   50n 100n)
Vb b gnd PULSE(0 1.8  10n 0n 0n   50n 100n)
Vc c gnd PULSE(0 1.8  20n 0n 0n   50n 100n)
Vd d gnd PULSE(0 1.8  30n 0n 0n   50n 100n)
Ve e gnd PULSE(0 1.8  40n 0n 0n   50n 100n)
VDD vdd gnd 1.8
M1 out a n1 gnd CMOSN W={4*width_N} L={L}
+ AS={5*4*width_N*LAMBDA} PS={10*LAMBDA+2*4*width_N} AD={5*4*width_N*LAMBDA} PD={10*LAMBDA+2*4*width_N}
M2 n1 b n2 gnd CMOSN W={4*width_N} L={L}
+ AS={5*4*width_N*LAMBDA} PS={10*LAMBDA+2*4*width_N} AD={5*4*width_N*LAMBDA} PD={10*LAMBDA+2*4*width_N}
M3 n2 c n3 gnd CMOSN W={4*width_N} L={L}
+ AS={5*4*width_N*LAMBDA} PS={10*LAMBDA+2*4*width_N} AD={5*4*width_N*LAMBDA} PD={10*LAMBDA+2*4*width_N}
M4 n3 d gnd gnd CMOSN W={4*width_N} L={L}
+ AS={5*4*width_N*LAMBDA} PS={10*LAMBDA+2*4*width_N} AD={5*4*width_N*LAMBDA} PD={10*LAMBDA+2*4*width_N}
M5 out a vdd vdd CMOSP W={width_P} L={L}
+ AS={5*width_P*LAMBDA} PS={10*LAMBDA+2*width_P} AD={5*width_P*LAMBDA} PD={10*LAMBDA+2*width_P}
M6 out b vdd vdd CMOSP W={width_P} L={L}
+ AS={5*width_P*LAMBDA} PS={10*LAMBDA+2*width_P} AD={5*width_P*LAMBDA} PD={10*LAMBDA+2*width_P}
M7 out c vdd vdd CMOSP W={width_P} L={L}
+ AS={5*width_P*LAMBDA} PS={10*LAMBDA+2*width_P} AD={5*width_P*LAMBDA} PD={10*LAMBDA+2*width_P}
M8 out d vdd vdd CMOSP W={width_P} L={L}
+ AS={5*width_P*LAMBDA} PS={10*LAMBDA+2*width_P} AD={5*width_P*LAMBDA} PD={10*LAMBDA+2*width_P}

.control

run
tran 0.1n 300n
set curplottitle="2024102057  4-input NAND Gate using CMOS"
plot v(a) v(b)+2 v(c)+4 v(d)+6 v(out)+8

.endc

.end
