* SPICE3 file created from NAND3.ext - technology: scmos

.option scale=0.09u
.include TSMC_180nm.txt
.param SUPPLY=1.8
.global gnd vdd
.param LAMBDA=0.09u
.param width_N=1.8u
.param width_P=2*width_N
.param L=2*LAMBDA

Va a gnd PULSE(0 1.8   0n 0n 0n   50n 100n)
Vb b gnd PULSE(0 1.8  10n 0n 0n   50n 100n)
Vc c gnd PULSE(0 1.8  20n 0n 0n   50n 100n)
VDD vdd gnd 1.8
M1000 vdd B out w_0_60# CMOSP w=40 l=2
+  ad=440 pd=182 as=440 ps=182
M1001 out C vdd w_0_60# CMOSP w=40 l=2
+  ad=0 pd=0 as=0 ps=0
M1002 out A vdd w_0_60# CMOSP w=40 l=2
+  ad=0 pd=0 as=0 ps=0
M1003 a_21_n12# B a_13_n12# Gnd CMOSN w=60 l=2
+  ad=360 pd=132 as=360 ps=132
M1004 a_13_n12# A out Gnd CMOSN w=60 l=2
+  ad=0 pd=0 as=300 ps=130
M1005 gnd C a_21_n12# Gnd CMOSN w=60 l=2
+  ad=300 pd=130 as=0 ps=0
C0 C vdd 0.10fF
C1 C w_0_60# 0.08fF
C2 B vdd 0.10fF
C3 B A 0.21fF
C4 vdd out 1.28fF
C5 out A 0.08fF
C6 B w_0_60# 0.08fF
C7 w_0_60# out 0.09fF
C8 C B 0.21fF
C9 C out 0.08fF
C10 a_13_n12# out 0.65fF
C11 B out 0.08fF
C12 a_21_n12# a_13_n12# 0.62fF
C13 a_21_n12# out 0.03fF
C14 a_13_n12# gnd 0.03fF
C15 vdd A 0.10fF
C16 gnd out 0.06fF
C17 w_0_60# vdd 0.11fF
C18 a_21_n12# gnd 0.65fF
C19 w_0_60# A 0.08fF
C20 gnd Gnd 0.10fF
C21 a_21_n12# Gnd 0.01fF
C22 a_13_n12# Gnd 0.01fF
C23 out Gnd 0.16fF
C24 vdd Gnd 0.07fF
C25 C Gnd 0.22fF
C26 B Gnd 0.22fF
C27 A Gnd 0.22fF
C28 w_0_60# Gnd 2.09fF

.control
run
tran 0.1n 300n
set curplottitle="2024102057  3-input NAND Gate using CMOS"
plot v(a) v(b)+2 v(c)+4 v(out)+6

.endc

.end
