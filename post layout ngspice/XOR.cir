* SPICE3 file created from XOR.ext - technology: scmos

.include TSMC_180nm.txt
.param SUPPLY=1.8
.global gnd vdd
.param LAMBDA=0.09u
.param width_N=1.8u
.param width_P=2*width_N
.param L=2*LAMBDA

Va a gnd PULSE(0 1.8   0n 0n 0n  50n 100n)
Vb b gnd PULSE(0 1.8  10n 0n 0n  50n 100n)
VDD vdd gnd 1.8

.option scale=0.09u

M1000 out a_157_n22# vdd w_317_14# CMOSP w=40 l=2
+  ad=240 pd=92 as=1600 ps=720
M1001 a_157_n22# a_1_n1# a_212_n22# Gnd CMOSN w=40 l=2
+  ad=200 pd=90 as=240 ps=92
M1002 a_1_n1# b vdd w_n5_n14# CMOSP w=40 l=2
+  ad=240 pd=92 as=0 ps=0
M1003 a_157_64# a_1_n1# vdd w_151_51# CMOSP w=40 l=2
+  ad=240 pd=92 as=0 ps=0
M1004 out a_157_64# a_378_27# Gnd CMOSN w=40 l=2
+  ad=200 pd=90 as=240 ps=92
M1005 vdd a_157_64# out w_317_14# CMOSP w=40 l=2
+  ad=0 pd=0 as=0 ps=0
M1006 a_212_n22# b gnd Gnd CMOSN w=40 l=2
+  ad=0 pd=0 as=800 ps=360
M1007 a_212_64# a_1_n1# gnd Gnd CMOSN w=40 l=2
+  ad=240 pd=92 as=0 ps=0
M1008 a_1_n1# a a_56_n1# Gnd CMOSN w=40 l=2
+  ad=200 pd=90 as=240 ps=92
M1009 vdd a_1_n1# a_157_n22# w_151_n35# CMOSP w=40 l=2
+  ad=0 pd=0 as=240 ps=92
M1010 vdd a a_157_64# w_151_51# CMOSP w=40 l=2
+  ad=0 pd=0 as=0 ps=0
M1011 a_157_64# a a_212_64# Gnd CMOSN w=40 l=2
+  ad=200 pd=90 as=0 ps=0
M1012 a_56_n1# b gnd Gnd CMOSN w=40 l=2
+  ad=0 pd=0 as=0 ps=0
M1013 a_157_n22# b vdd w_151_n35# CMOSP w=40 l=2
+  ad=0 pd=0 as=0 ps=0
M1014 vdd a a_1_n1# w_n5_n14# CMOSP w=40 l=2
+  ad=0 pd=0 as=0 ps=0
M1015 a_378_27# a_157_n22# gnd Gnd CMOSN w=40 l=2
+  ad=0 pd=0 as=0 ps=0
C0 b w_n5_n14# 0.08fF
C1 a_56_n1# gnd 0.41fF
C2 a_1_n1# w_151_n35# 0.08fF
C3 vdd w_151_n35# 0.14fF
C4 w_317_14# a_157_64# 0.08fF
C5 a_1_n1# a_157_n22# 0.08fF
C6 a_157_n22# vdd 1.12fF
C7 a_1_n1# a 1.53fF
C8 vdd a 0.29fF
C9 w_151_51# a_157_64# 0.02fF
C10 a_378_27# out 0.47fF
C11 b w_151_n35# 0.08fF
C12 a_212_n22# gnd 0.41fF
C13 gnd a_212_64# 0.41fF
C14 vdd out 0.88fF
C15 a_1_n1# vdd 1.39fF
C16 a_157_n22# gnd 0.02fF
C17 a_157_n22# w_317_14# 0.08fF
C18 b a 0.22fF
C19 a_212_64# a_157_64# 0.47fF
C20 w_n5_n14# a 0.08fF
C21 a_378_27# gnd 0.41fF
C22 a_1_n1# gnd 0.01fF
C23 a_1_n1# b 0.23fF
C24 a_157_n22# a_157_64# 0.23fF
C25 vdd gnd 1.45fF
C26 a w_151_51# 0.08fF
C27 vdd b 0.36fF
C28 out w_317_14# 0.02fF
C29 a a_157_64# 0.08fF
C30 a_1_n1# w_n5_n14# 0.02fF
C31 a_1_n1# a_56_n1# 0.47fF
C32 vdd w_317_14# 0.14fF
C33 vdd w_n5_n14# 0.14fF
C34 a_1_n1# w_151_51# 0.08fF
C35 out a_157_64# 0.08fF
C36 vdd w_151_51# 0.14fF
C37 a_157_n22# w_151_n35# 0.02fF
C38 a_157_n22# a_212_n22# 0.47fF
C39 vdd a_157_64# 1.68fF
C40 a_212_n22# Gnd 0.01fF
C41 a_56_n1# Gnd 0.01fF
C42 b Gnd 1.15fF
C43 a_378_27# Gnd 0.01fF
C44 a_157_n22# Gnd 0.70fF
C45 out Gnd 0.13fF
C46 gnd Gnd 1.66fF
C47 a_212_64# Gnd 0.01fF
C48 a_1_n1# Gnd 1.30fF
C49 a_157_64# Gnd 0.78fF
C50 a Gnd 1.07fF
C51 vdd Gnd 1.74fF
C52 w_151_n35# Gnd 1.67fF
C53 w_317_14# Gnd 1.67fF
C54 w_n5_n14# Gnd 1.67fF
C55 w_151_51# Gnd 1.67fF

.control

run
tran 0.1n 300n

set curplottitle="2024102057  2-input XOR Gate using NAND2 Gates"
plot v(a) v(b)+2 v(out)+4

.endc

.end
