* SPICE3 file created from SUM2.ext - technology: scmos
* 5-bit Carry-Lookahead Adder - NAND-only (NAND2..NAND6, XOR2, INV)
.include TSMC_180nm.txt
.param SUPPLY=1.8
.global gnd vdd
.param LAMBDA=0.09u
.param width_N=1.8u
.param width_P=2*width_N
.param L=2*LAMBDA

.option scale=0.09u

M1000 a_698_1711# a_647_1760# gnd Gnd CMOSN w=20 l=2
+  ad=100 pd=50 as=15300 ps=6714
M1001 a_386_844# a_332_1025# vdd w_380_831# CMOSP w=40 l=2
+  ad=200 pd=90 as=27960 ps=12358
M1002 a_434_696# a_223_631# gnd Gnd CMOSN w=40 l=2
+  ad=240 pd=92 as=0 ps=0
M1003 a_379_610# B3 vdd w_373_597# CMOSP w=40 l=2
+  ad=240 pd=92 as=0 ps=0
M1004 a_208_1131# A2 a_263_1131# Gnd CMOSN w=40 l=2
+  ad=200 pd=90 as=240 ps=92
M1005 a_808_1394# a_806_1390# a_800_1394# Gnd CMOSN w=60 l=2
+  ad=360 pd=132 as=360 ps=132
M1006 vdd a_545_659# a_1157_9# w_1440_382# CMOSP w=40 l=2
+  ad=0 pd=0 as=680 ps=274
M1007 vdd C1 a_2240_1784# w_2234_1771# CMOSP w=40 l=2
+  ad=0 pd=0 as=240 ps=92
M1008 S2 a_2240_1698# vdd w_2400_1734# CMOSP w=40 l=2
+  ad=240 pd=92 as=0 ps=0
M1009 a_585_1159# a_364_1110# gnd Gnd CMOSN w=40 l=2
+  ad=240 pd=92 as=0 ps=0
M1010 a_382_1341# B1 vdd w_382_1394# CMOSP w=40 l=2
+  ad=240 pd=92 as=0 ps=0
M1011 a_958_1876# a_792_1913# a_1013_1876# Gnd CMOSN w=40 l=2
+  ad=200 pd=90 as=240 ps=92
M1012 a_814_1390# cin vdd w_997_1601# CMOSP w=40 l=2
+  ad=440 pd=182 as=0 ps=0
M1013 a_724_379# a_534_279# vdd w_718_366# CMOSP w=40 l=2
+  ad=240 pd=92 as=0 ps=0
M1014 a_545_659# a_379_696# a_600_659# Gnd CMOSN w=40 l=2
+  ad=200 pd=90 as=240 ps=92
M1015 gnd a_545_659# a_1009_861# Gnd CMOSN w=60 l=2
+  ad=0 pd=0 as=360 ps=132
M1016 a_2126_686# a_534_279# a_2181_686# Gnd CMOSN w=40 l=2
+  ad=200 pd=90 as=240 ps=92
M1017 vdd a_534_279# a_1970_621# w_1964_608# CMOSP w=40 l=2
+  ad=0 pd=0 as=240 ps=92
M1018 a_368_230# B4 vdd w_362_217# CMOSP w=40 l=2
+  ad=240 pd=92 as=0 ps=0
M1019 vdd a_2065_1948# a_2221_1927# w_2215_1914# CMOSP w=40 l=2
+  ad=0 pd=0 as=240 ps=92
M1020 gnd a_545_659# a_1225_873# Gnd CMOSN w=80 l=2
+  ad=0 pd=0 as=480 ps=172
M1021 a_1143_13# a_917_383# a_1135_13# Gnd CMOSN w=100 l=2
+  ad=600 pd=212 as=600 ps=212
M1022 a_338_399# a_322_397# vdd w_332_386# CMOSP w=40 l=2
+  ad=200 pd=90 as=0 ps=0
M1023 a_922_1342# a_549_1529# vdd w_916_1329# CMOSP w=40 l=2
+  ad=440 pd=182 as=0 ps=0
M1024 a_2004_1008# C3 a_2059_1008# Gnd CMOSN w=40 l=2
+  ad=200 pd=90 as=240 ps=92
M1025 gnd a_386_844# a_807_843# Gnd CMOSN w=40 l=2
+  ad=0 pd=0 as=240 ps=92
M1026 a_782_379# a_534_279# a_724_379# Gnd CMOSN w=40 l=2
+  ad=240 pd=92 as=200 ps=90
M1027 vdd a_534_279# a_1149_9# w_1171_350# CMOSP w=40 l=2
+  ad=0 pd=0 as=480 ps=184
M1028 a_980_1350# a_698_1711# a_980_1342# Gnd CMOSN w=60 l=2
+  ad=360 pd=132 as=360 ps=132
M1029 a_534_279# a_368_316# a_589_279# Gnd CMOSN w=40 l=2
+  ad=200 pd=90 as=240 ps=92
M1030 a_338_399# a_322_397# gnd Gnd CMOSN w=20 l=2
+  ad=100 pd=50 as=0 ps=0
M1031 gnd a_534_279# a_1504_419# Gnd CMOSN w=100 l=2
+  ad=0 pd=0 as=600 ps=212
M1032 a_423_316# a_212_251# gnd Gnd CMOSN w=40 l=2
+  ad=240 pd=92 as=0 ps=0
M1033 a_1329_946# a_733_1307# a_1321_946# Gnd CMOSN w=80 l=2
+  ad=480 pd=172 as=480 ps=172
M1034 a_998_529# a_698_1711# vdd w_1161_844# CMOSP w=40 l=2
+  ad=480 pd=184 as=0 ps=0
M1035 vdd a_958_1876# a_1174_1352# w_1168_1339# CMOSP w=40 l=2
+  ad=0 pd=0 as=480 ps=184
M1036 a_2215_1073# a_2004_1008# gnd Gnd CMOSN w=40 l=2
+  ad=240 pd=92 as=0 ps=0
M1037 gnd A1 a_446_1407# Gnd CMOSN w=40 l=2
+  ad=0 pd=0 as=240 ps=92
M1038 vdd a_724_379# C5 w_1114_125# CMOSP w=40 l=2
+  ad=0 pd=0 as=680 ps=274
M1039 vdd a_958_1876# a_2065_1948# w_2059_1935# CMOSP w=40 l=2
+  ad=0 pd=0 as=240 ps=92
M1040 a_364_1110# a_208_1131# a_419_1110# Gnd CMOSN w=40 l=2
+  ad=200 pd=90 as=240 ps=92
M1041 S4 a_2160_1073# a_2381_1036# Gnd CMOSN w=40 l=2
+  ad=200 pd=90 as=240 ps=92
M1042 a_2004_1008# a_545_659# vdd w_1998_995# CMOSP w=40 l=2
+  ad=240 pd=92 as=0 ps=0
M1043 a_2215_987# a_545_659# gnd Gnd CMOSN w=40 l=2
+  ad=240 pd=92 as=0 ps=0
M1044 vdd a_545_659# a_917_383# w_911_370# CMOSP w=40 l=2
+  ad=0 pd=0 as=440 ps=182
M1045 vdd a_549_1529# a_1157_9# w_1440_382# CMOSP w=40 l=2
+  ad=0 pd=0 as=0 ps=0
M1046 vdd a_2004_1008# a_2160_987# w_2154_974# CMOSP w=40 l=2
+  ad=0 pd=0 as=240 ps=92
M1047 S1 a_2221_1927# vdd w_2381_1963# CMOSP w=40 l=2
+  ad=240 pd=92 as=0 ps=0
M1048 a_2240_1698# a_2084_1719# a_2295_1698# Gnd CMOSN w=40 l=2
+  ad=200 pd=90 as=240 ps=92
M1049 a_223_631# A3 a_278_631# Gnd CMOSN w=40 l=2
+  ad=200 pd=90 as=240 ps=92
M1050 a_545_659# a_379_610# vdd w_539_646# CMOSP w=40 l=2
+  ad=240 pd=92 as=0 ps=0
M1051 S1 a_2221_2013# a_2442_1976# Gnd CMOSN w=40 l=2
+  ad=200 pd=90 as=240 ps=92
M1052 a_698_1711# a_647_1760# vdd w_692_1698# CMOSP w=40 l=2
+  ad=200 pd=90 as=0 ps=0
M1053 a_874_1613# a_549_1529# a_806_1390# Gnd CMOSN w=40 l=2
+  ad=240 pd=92 as=200 ps=90
M1054 a_814_1390# a_549_1529# vdd w_997_1601# CMOSP w=40 l=2
+  ad=0 pd=0 as=0 ps=0
M1055 C2 a_382_1341# vdd w_787_1466# CMOSP w=40 l=2
+  ad=440 pd=182 as=0 ps=0
M1056 gnd a_530_1159# a_791_1307# Gnd CMOSN w=40 l=2
+  ad=0 pd=0 as=240 ps=92
M1057 a_2160_1073# a_2004_1008# vdd w_2154_1060# CMOSP w=40 l=2
+  ad=240 pd=92 as=0 ps=0
M1058 a_332_1025# B2 vdd w_326_1012# CMOSP w=40 l=2
+  ad=240 pd=92 as=0 ps=0
M1059 vdd A0 a_636_1848# w_630_1835# CMOSP w=40 l=2
+  ad=0 pd=0 as=240 ps=92
M1060 a_975_391# a_545_659# a_975_383# Gnd CMOSN w=60 l=2
+  ad=360 pd=132 as=360 ps=132
M1061 a_383_1566# A1 a_438_1566# Gnd CMOSN w=40 l=2
+  ad=200 pd=90 as=240 ps=92
M1062 a_2181_1465# C2 a_2236_1465# Gnd CMOSN w=40 l=2
+  ad=200 pd=90 as=240 ps=92
M1063 a_1009_853# a_398_1343# a_951_853# Gnd CMOSN w=60 l=2
+  ad=360 pd=132 as=300 ps=130
M1064 vdd a_208_1131# a_364_1110# w_358_1097# CMOSP w=40 l=2
+  ad=0 pd=0 as=240 ps=92
M1065 a_2240_1698# a_549_1529# vdd w_2234_1685# CMOSP w=40 l=2
+  ad=240 pd=92 as=0 ps=0
M1066 a_1225_865# a_549_1529# a_1225_857# Gnd CMOSN w=80 l=2
+  ad=480 pd=172 as=480 ps=172
M1067 a_958_1876# a_792_1827# vdd w_952_1863# CMOSP w=40 l=2
+  ad=240 pd=92 as=0 ps=0
M1068 vdd A1 a_227_1501# w_221_1488# CMOSP w=40 l=2
+  ad=0 pd=0 as=240 ps=92
M1069 a_282_1501# B1 gnd Gnd CMOSN w=40 l=2
+  ad=240 pd=92 as=0 ps=0
M1070 vdd C2 a_2025_1400# w_2019_1387# CMOSP w=40 l=2
+  ad=0 pd=0 as=240 ps=92
M1071 a_1232_1368# a_549_1529# a_1232_1360# Gnd CMOSN w=80 l=2
+  ad=480 pd=172 as=480 ps=172
M1072 a_2347_649# a_2126_600# gnd Gnd CMOSN w=40 l=2
+  ad=240 pd=92 as=0 ps=0
M1073 C2 a_814_1390# vdd w_787_1466# CMOSP w=40 l=2
+  ad=0 pd=0 as=0 ps=0
M1074 a_2080_1400# a_530_1159# gnd Gnd CMOSN w=40 l=2
+  ad=240 pd=92 as=0 ps=0
M1075 a_691_1848# B0 gnd Gnd CMOSN w=40 l=2
+  ad=240 pd=92 as=0 ps=0
M1076 vdd a_530_1159# a_951_853# w_945_840# CMOSP w=40 l=2
+  ad=0 pd=0 as=440 ps=182
M1077 vdd a_534_279# a_2126_686# w_2120_673# CMOSP w=40 l=2
+  ad=0 pd=0 as=240 ps=92
M1078 a_322_397# A3 vdd w_318_489# CMOSP w=40 l=2
+  ad=240 pd=92 as=0 ps=0
M1079 a_2181_600# C4 gnd Gnd CMOSN w=40 l=2
+  ad=240 pd=92 as=0 ps=0
M1080 vdd a_2126_686# S5 w_2286_636# CMOSP w=40 l=2
+  ad=0 pd=0 as=240 ps=92
M1081 vdd A1 a_383_1566# w_377_1553# CMOSP w=40 l=2
+  ad=0 pd=0 as=240 ps=92
M1082 a_549_1529# a_383_1480# vdd w_543_1516# CMOSP w=40 l=2
+  ad=240 pd=92 as=0 ps=0
M1083 vdd C2 a_2181_1465# w_2175_1452# CMOSP w=40 l=2
+  ad=0 pd=0 as=240 ps=92
M1084 S3 a_2181_1379# vdd w_2341_1415# CMOSP w=40 l=2
+  ad=240 pd=92 as=0 ps=0
M1085 a_534_279# a_368_230# vdd w_528_266# CMOSP w=40 l=2
+  ad=240 pd=92 as=0 ps=0
M1086 a_1235_371# a_398_1343# a_1235_363# Gnd CMOSN w=80 l=2
+  ad=480 pd=172 as=480 ps=172
M1087 a_705_1760# A0 a_647_1760# Gnd CMOSN w=40 l=2
+  ad=240 pd=92 as=200 ps=90
M1088 a_878_1761# a_647_1760# C1 Gnd CMOSN w=40 l=2
+  ad=240 pd=92 as=200 ps=90
M1089 a_549_1529# a_383_1566# a_604_1529# Gnd CMOSN w=40 l=2
+  ad=200 pd=90 as=240 ps=92
M1090 S3 a_2181_1465# a_2402_1428# Gnd CMOSN w=40 l=2
+  ad=200 pd=90 as=240 ps=92
M1091 C3 a_922_1342# vdd w_1308_1038# CMOSP w=40 l=2
+  ad=480 pd=184 as=0 ps=0
M1092 a_212_251# A4 a_267_251# Gnd CMOSN w=40 l=2
+  ad=200 pd=90 as=240 ps=92
M1093 vdd a_698_1711# a_806_1390# w_810_1600# CMOSP w=40 l=2
+  ad=0 pd=0 as=240 ps=92
M1094 vdd B4 a_336_162# w_330_149# CMOSP w=40 l=2
+  ad=0 pd=0 as=240 ps=92
M1095 vdd a_545_659# a_998_529# w_1161_844# CMOSP w=40 l=2
+  ad=0 pd=0 as=0 ps=0
M1096 a_382_502# A3 a_322_397# Gnd CMOSN w=40 l=2
+  ad=240 pd=92 as=200 ps=90
M1097 a_984_532# a_749_843# C4 Gnd CMOSN w=80 l=2
+  ad=480 pd=172 as=400 ps=170
M1098 vdd a_223_631# a_379_610# w_373_597# CMOSP w=40 l=2
+  ad=0 pd=0 as=0 ps=0
M1099 vdd a_386_844# a_749_843# w_743_830# CMOSP w=40 l=2
+  ad=0 pd=0 as=240 ps=92
M1100 a_1127_13# a_336_162# C5 Gnd CMOSN w=100 l=2
+  ad=600 pd=212 as=500 ps=210
M1101 a_2139_1719# a_549_1529# gnd Gnd CMOSN w=40 l=2
+  ad=240 pd=92 as=0 ps=0
M1102 a_419_1196# a_208_1131# gnd Gnd CMOSN w=40 l=2
+  ad=240 pd=92 as=0 ps=0
M1103 vdd a_1149_9# C5 w_1114_125# CMOSP w=40 l=2
+  ad=0 pd=0 as=0 ps=0
M1104 a_800_1394# a_382_1341# C2 Gnd CMOSN w=60 l=2
+  ad=0 pd=0 as=300 ps=130
M1105 gnd B4 a_394_162# Gnd CMOSN w=40 l=2
+  ad=0 pd=0 as=240 ps=92
M1106 a_1157_9# a_534_279# vdd w_1440_382# CMOSP w=40 l=2
+  ad=0 pd=0 as=0 ps=0
M1107 a_2295_1784# a_2084_1719# gnd Gnd CMOSN w=40 l=2
+  ad=240 pd=92 as=0 ps=0
M1108 vdd a_2240_1784# S2 w_2400_1734# CMOSP w=40 l=2
+  ad=0 pd=0 as=0 ps=0
M1109 a_530_1159# a_364_1196# a_585_1159# Gnd CMOSN w=40 l=2
+  ad=200 pd=90 as=0 ps=0
M1110 a_223_631# B3 vdd w_217_618# CMOSP w=40 l=2
+  ad=240 pd=92 as=0 ps=0
M1111 a_208_1131# B2 vdd w_202_1118# CMOSP w=40 l=2
+  ad=240 pd=92 as=0 ps=0
M1112 a_1337_946# a_922_1342# a_1329_946# Gnd CMOSN w=80 l=2
+  ad=480 pd=172 as=0 ps=0
M1113 vdd a_958_1876# a_2221_2013# w_2215_2000# CMOSP w=40 l=2
+  ad=0 pd=0 as=240 ps=92
M1114 a_800_1767# cin vdd w_979_1769# CMOSP w=40 l=2
+  ad=240 pd=92 as=0 ps=0
M1115 vdd A1 a_382_1341# w_382_1394# CMOSP w=40 l=2
+  ad=0 pd=0 as=0 ps=0
M1116 a_379_696# A3 a_434_696# Gnd CMOSN w=40 l=2
+  ad=200 pd=90 as=0 ps=0
M1117 vdd a_338_399# a_724_379# w_718_366# CMOSP w=40 l=2
+  ad=0 pd=0 as=0 ps=0
M1118 a_2084_1719# a_549_1529# vdd w_2078_1706# CMOSP w=40 l=2
+  ad=240 pd=92 as=0 ps=0
M1119 a_364_1196# a_208_1131# vdd w_358_1183# CMOSP w=40 l=2
+  ad=240 pd=92 as=0 ps=0
M1120 C5 a_917_383# vdd w_1114_125# CMOSP w=40 l=2
+  ad=0 pd=0 as=0 ps=0
M1121 gnd a_814_1390# a_808_1394# Gnd CMOSN w=60 l=2
+  ad=0 pd=0 as=0 ps=0
M1122 vdd a_212_251# a_368_230# w_362_217# CMOSP w=40 l=2
+  ad=0 pd=0 as=0 ps=0
M1123 a_2276_1927# cin gnd Gnd CMOSN w=40 l=2
+  ad=240 pd=92 as=0 ps=0
M1124 a_2461_1747# a_2240_1698# gnd Gnd CMOSN w=40 l=2
+  ad=240 pd=92 as=0 ps=0
M1125 a_1232_1352# cin a_1174_1352# Gnd CMOSN w=80 l=2
+  ad=480 pd=172 as=400 ps=170
M1126 gnd a_338_399# a_782_379# Gnd CMOSN w=40 l=2
+  ad=0 pd=0 as=0 ps=0
M1127 gnd a_530_1159# a_980_1350# Gnd CMOSN w=60 l=2
+  ad=0 pd=0 as=0 ps=0
M1128 gnd a_322_397# a_1000_532# Gnd CMOSN w=80 l=2
+  ad=0 pd=0 as=480 ps=172
M1129 a_2025_621# C4 gnd Gnd CMOSN w=40 l=2
+  ad=240 pd=92 as=0 ps=0
M1130 a_438_1480# B1 gnd Gnd CMOSN w=40 l=2
+  ad=240 pd=92 as=0 ps=0
M1131 a_2236_1379# a_530_1159# gnd Gnd CMOSN w=40 l=2
+  ad=240 pd=92 as=0 ps=0
M1132 a_2276_2013# a_2065_1948# gnd Gnd CMOSN w=40 l=2
+  ad=240 pd=92 as=0 ps=0
M1133 a_847_1827# B0 gnd Gnd CMOSN w=40 l=2
+  ad=240 pd=92 as=0 ps=0
M1134 a_733_1307# a_398_1343# vdd w_727_1294# CMOSP w=40 l=2
+  ad=240 pd=92 as=0 ps=0
M1135 a_530_1159# a_364_1110# vdd w_524_1146# CMOSP w=40 l=2
+  ad=240 pd=92 as=0 ps=0
M1136 a_212_251# B4 vdd w_206_238# CMOSP w=40 l=2
+  ad=240 pd=92 as=0 ps=0
M1137 a_368_316# A4 a_423_316# Gnd CMOSN w=40 l=2
+  ad=200 pd=90 as=0 ps=0
M1138 vdd a_549_1529# a_998_529# w_1161_844# CMOSP w=40 l=2
+  ad=0 pd=0 as=0 ps=0
M1139 a_379_696# a_223_631# vdd w_373_683# CMOSP w=40 l=2
+  ad=240 pd=92 as=0 ps=0
M1140 a_1174_1352# a_549_1529# vdd w_1168_1339# CMOSP w=40 l=2
+  ad=0 pd=0 as=0 ps=0
M1141 a_2126_600# C4 vdd w_2120_587# CMOSP w=40 l=2
+  ad=240 pd=92 as=0 ps=0
M1142 a_383_1480# B1 vdd w_377_1467# CMOSP w=40 l=2
+  ad=240 pd=92 as=0 ps=0
M1143 a_2181_1379# a_530_1159# vdd w_2175_1366# CMOSP w=40 l=2
+  ad=240 pd=92 as=0 ps=0
M1144 a_1000_532# a_998_529# a_992_532# Gnd CMOSN w=80 l=2
+  ad=0 pd=0 as=480 ps=172
M1145 a_792_1913# A0 a_847_1913# Gnd CMOSN w=40 l=2
+  ad=200 pd=90 as=240 ps=92
M1146 a_792_1827# B0 vdd w_786_1814# CMOSP w=40 l=2
+  ad=240 pd=92 as=0 ps=0
M1147 a_647_1760# A0 vdd w_641_1747# CMOSP w=40 l=2
+  ad=240 pd=92 as=0 ps=0
M1148 vdd C3 a_2004_1008# w_1998_995# CMOSP w=40 l=2
+  ad=0 pd=0 as=0 ps=0
M1149 a_2160_987# a_2004_1008# a_2215_987# Gnd CMOSN w=40 l=2
+  ad=200 pd=90 as=0 ps=0
M1150 vdd a_398_1343# a_1149_9# w_1171_350# CMOSP w=40 l=2
+  ad=0 pd=0 as=0 ps=0
M1151 a_917_383# a_534_279# vdd w_911_370# CMOSP w=40 l=2
+  ad=0 pd=0 as=0 ps=0
M1152 vdd a_2221_2013# S1 w_2381_1963# CMOSP w=40 l=2
+  ad=0 pd=0 as=0 ps=0
M1153 vdd a_379_696# a_545_659# w_539_646# CMOSP w=40 l=2
+  ad=0 pd=0 as=0 ps=0
M1154 vdd a_958_1876# a_814_1390# w_997_1601# CMOSP w=40 l=2
+  ad=0 pd=0 as=0 ps=0
M1155 vdd A2 a_332_1025# w_326_1012# CMOSP w=40 l=2
+  ad=0 pd=0 as=0 ps=0
M1156 S4 a_2160_987# vdd w_2320_1023# CMOSP w=40 l=2
+  ad=240 pd=92 as=0 ps=0
M1157 gnd a_958_1876# a_1043_1782# Gnd CMOSN w=40 l=2
+  ad=0 pd=0 as=240 ps=92
M1158 gnd cin a_1061_1622# Gnd CMOSN w=60 l=2
+  ad=0 pd=0 as=360 ps=132
M1159 a_1151_13# a_1149_9# a_1143_13# Gnd CMOSN w=100 l=2
+  ad=600 pd=212 as=0 ps=0
M1160 a_1504_411# a_530_1159# a_1504_403# Gnd CMOSN w=100 l=2
+  ad=600 pd=212 as=600 ps=212
M1161 a_992_532# a_951_853# a_984_532# Gnd CMOSN w=80 l=2
+  ad=0 pd=0 as=0 ps=0
M1162 vdd A0 a_792_1913# w_786_1900# CMOSP w=40 l=2
+  ad=0 pd=0 as=240 ps=92
M1163 gnd a_534_279# a_975_391# Gnd CMOSN w=60 l=2
+  ad=0 pd=0 as=0 ps=0
M1164 a_1225_873# a_530_1159# a_1225_865# Gnd CMOSN w=80 l=2
+  ad=0 pd=0 as=0 ps=0
M1165 C5 a_1157_9# vdd w_1114_125# CMOSP w=40 l=2
+  ad=0 pd=0 as=0 ps=0
M1166 vdd a_792_1913# a_958_1876# w_952_1863# CMOSP w=40 l=2
+  ad=0 pd=0 as=0 ps=0
M1167 gnd a_530_1159# a_1232_1368# Gnd CMOSN w=80 l=2
+  ad=0 pd=0 as=0 ps=0
M1168 a_980_1342# a_549_1529# a_922_1342# Gnd CMOSN w=60 l=2
+  ad=0 pd=0 as=300 ps=130
M1169 a_807_843# a_545_659# a_749_843# Gnd CMOSN w=40 l=2
+  ad=0 pd=0 as=200 ps=90
M1170 a_434_610# B3 gnd Gnd CMOSN w=40 l=2
+  ad=240 pd=92 as=0 ps=0
M1171 S5 a_2126_686# a_2347_649# Gnd CMOSN w=40 l=2
+  ad=200 pd=90 as=0 ps=0
M1172 a_2120_1948# cin gnd Gnd CMOSN w=40 l=2
+  ad=240 pd=92 as=0 ps=0
M1173 gnd a_1174_1352# a_1337_946# Gnd CMOSN w=80 l=2
+  ad=0 pd=0 as=0 ps=0
M1174 C4 a_749_843# vdd w_971_624# CMOSP w=40 l=2
+  ad=480 pd=184 as=0 ps=0
M1175 a_636_1848# A0 a_691_1848# Gnd CMOSN w=40 l=2
+  ad=200 pd=90 as=0 ps=0
M1176 C1 a_647_1760# vdd w_814_1748# CMOSP w=40 l=2
+  ad=240 pd=92 as=0 ps=0
M1177 C3 a_332_1025# vdd w_1308_1038# CMOSP w=40 l=2
+  ad=0 pd=0 as=0 ps=0
M1178 a_951_853# a_545_659# vdd w_945_840# CMOSP w=40 l=2
+  ad=0 pd=0 as=0 ps=0
M1179 vdd a_383_1566# a_549_1529# w_543_1516# CMOSP w=40 l=2
+  ad=0 pd=0 as=0 ps=0
M1180 vdd a_2181_1465# S3 w_2341_1415# CMOSP w=40 l=2
+  ad=0 pd=0 as=0 ps=0
M1181 vdd a_368_316# a_534_279# w_528_266# CMOSP w=40 l=2
+  ad=0 pd=0 as=0 ps=0
M1182 a_368_316# a_212_251# vdd w_362_303# CMOSP w=40 l=2
+  ad=240 pd=92 as=0 ps=0
M1183 a_1235_379# a_545_659# a_1235_371# Gnd CMOSN w=80 l=2
+  ad=480 pd=172 as=0 ps=0
M1184 gnd B0 a_705_1760# Gnd CMOSN w=40 l=2
+  ad=0 pd=0 as=0 ps=0
M1185 gnd a_800_1767# a_878_1761# Gnd CMOSN w=40 l=2
+  ad=0 pd=0 as=0 ps=0
M1186 vdd a_2084_1719# a_2240_1698# w_2234_1685# CMOSP w=40 l=2
+  ad=0 pd=0 as=0 ps=0
M1187 a_1174_1352# cin vdd w_1168_1339# CMOSP w=40 l=2
+  ad=0 pd=0 as=0 ps=0
M1188 a_227_1501# A1 a_282_1501# Gnd CMOSN w=40 l=2
+  ad=200 pd=90 as=0 ps=0
M1189 a_2025_1400# C2 a_2080_1400# Gnd CMOSN w=40 l=2
+  ad=200 pd=90 as=0 ps=0
M1190 a_1504_395# a_698_1711# a_1157_9# Gnd CMOSN w=100 l=2
+  ad=600 pd=212 as=500 ps=210
M1191 a_2126_600# a_1970_621# a_2181_600# Gnd CMOSN w=40 l=2
+  ad=200 pd=90 as=0 ps=0
M1192 a_2084_1719# C1 a_2139_1719# Gnd CMOSN w=40 l=2
+  ad=200 pd=90 as=0 ps=0
M1193 vdd a_1174_1352# C3 w_1308_1038# CMOSP w=40 l=2
+  ad=0 pd=0 as=0 ps=0
M1194 a_423_230# B4 gnd Gnd CMOSN w=40 l=2
+  ad=240 pd=92 as=0 ps=0
M1195 a_917_383# a_386_844# vdd w_911_370# CMOSP w=40 l=2
+  ad=0 pd=0 as=0 ps=0
M1196 vdd a_698_1711# a_922_1342# w_916_1329# CMOSP w=40 l=2
+  ad=0 pd=0 as=0 ps=0
M1197 a_398_1343# a_382_1341# gnd Gnd CMOSN w=20 l=2
+  ad=100 pd=50 as=0 ps=0
M1198 a_2240_1784# C1 a_2295_1784# Gnd CMOSN w=40 l=2
+  ad=200 pd=90 as=0 ps=0
M1199 vdd A3 a_223_631# w_217_618# CMOSP w=40 l=2
+  ad=0 pd=0 as=0 ps=0
M1200 vdd A2 a_208_1131# w_202_1118# CMOSP w=40 l=2
+  ad=0 pd=0 as=0 ps=0
M1201 vdd a_322_397# C4 w_971_624# CMOSP w=40 l=2
+  ad=0 pd=0 as=0 ps=0
M1202 a_1061_1614# a_549_1529# a_814_1390# Gnd CMOSN w=60 l=2
+  ad=360 pd=132 as=300 ps=130
M1203 a_390_1025# B2 a_332_1025# Gnd CMOSN w=40 l=2
+  ad=240 pd=92 as=200 ps=90
M1204 vdd C1 a_2084_1719# w_2078_1706# CMOSP w=40 l=2
+  ad=0 pd=0 as=0 ps=0
M1205 a_364_1196# A2 a_419_1196# Gnd CMOSN w=40 l=2
+  ad=200 pd=90 as=0 ps=0
M1206 a_975_383# a_386_844# a_917_383# Gnd CMOSN w=60 l=2
+  ad=0 pd=0 as=300 ps=130
M1207 a_2221_1927# a_2065_1948# a_2276_1927# Gnd CMOSN w=40 l=2
+  ad=200 pd=90 as=0 ps=0
M1208 a_2160_1073# C3 a_2215_1073# Gnd CMOSN w=40 l=2
+  ad=200 pd=90 as=0 ps=0
M1209 S2 a_2240_1784# a_2461_1747# Gnd CMOSN w=40 l=2
+  ad=200 pd=90 as=0 ps=0
M1210 a_263_1131# B2 gnd Gnd CMOSN w=40 l=2
+  ad=0 pd=0 as=0 ps=0
M1211 a_1135_13# a_724_379# a_1127_13# Gnd CMOSN w=100 l=2
+  ad=0 pd=0 as=0 ps=0
M1212 a_1970_621# a_534_279# a_2025_621# Gnd CMOSN w=40 l=2
+  ad=200 pd=90 as=0 ps=0
M1213 a_383_1480# a_227_1501# a_438_1480# Gnd CMOSN w=40 l=2
+  ad=200 pd=90 as=0 ps=0
M1214 a_2181_1379# a_2025_1400# a_2236_1379# Gnd CMOSN w=40 l=2
+  ad=200 pd=90 as=0 ps=0
M1215 a_951_853# a_398_1343# vdd w_945_840# CMOSP w=40 l=2
+  ad=0 pd=0 as=0 ps=0
M1216 vdd A2 a_364_1196# w_358_1183# CMOSP w=40 l=2
+  ad=0 pd=0 as=0 ps=0
M1217 a_1235_363# a_530_1159# a_1149_9# Gnd CMOSN w=80 l=2
+  ad=0 pd=0 as=400 ps=170
M1218 a_1157_9# a_530_1159# vdd w_1440_382# CMOSP w=40 l=2
+  ad=0 pd=0 as=0 ps=0
M1219 C4 a_998_529# vdd w_971_624# CMOSP w=40 l=2
+  ad=0 pd=0 as=0 ps=0
M1220 a_792_1827# a_636_1848# a_847_1827# Gnd CMOSN w=40 l=2
+  ad=200 pd=90 as=0 ps=0
M1221 a_2240_1784# a_2084_1719# vdd w_2234_1771# CMOSP w=40 l=2
+  ad=0 pd=0 as=0 ps=0
M1222 vdd a_364_1196# a_530_1159# w_524_1146# CMOSP w=40 l=2
+  ad=0 pd=0 as=0 ps=0
M1223 vdd A4 a_212_251# w_206_238# CMOSP w=40 l=2
+  ad=0 pd=0 as=0 ps=0
M1224 a_806_1390# a_549_1529# vdd w_810_1600# CMOSP w=40 l=2
+  ad=0 pd=0 as=0 ps=0
M1225 vdd a_530_1159# a_733_1307# w_727_1294# CMOSP w=40 l=2
+  ad=0 pd=0 as=0 ps=0
M1226 a_336_162# A4 vdd w_330_149# CMOSP w=40 l=2
+  ad=0 pd=0 as=0 ps=0
M1227 a_1013_1876# a_792_1827# gnd Gnd CMOSN w=40 l=2
+  ad=0 pd=0 as=0 ps=0
M1228 gnd a_698_1711# a_874_1613# Gnd CMOSN w=40 l=2
+  ad=0 pd=0 as=0 ps=0
M1229 vdd C3 a_2160_1073# w_2154_1060# CMOSP w=40 l=2
+  ad=0 pd=0 as=0 ps=0
M1230 a_998_529# a_530_1159# vdd w_1161_844# CMOSP w=40 l=2
+  ad=0 pd=0 as=0 ps=0
M1231 a_600_659# a_379_610# gnd Gnd CMOSN w=40 l=2
+  ad=0 pd=0 as=0 ps=0
M1232 vdd a_530_1159# a_1174_1352# w_1168_1339# CMOSP w=40 l=2
+  ad=0 pd=0 as=0 ps=0
M1233 a_1009_861# a_530_1159# a_1009_853# Gnd CMOSN w=60 l=2
+  ad=0 pd=0 as=0 ps=0
M1234 a_749_843# a_545_659# vdd w_743_830# CMOSP w=40 l=2
+  ad=0 pd=0 as=0 ps=0
M1235 a_2181_686# a_1970_621# gnd Gnd CMOSN w=40 l=2
+  ad=0 pd=0 as=0 ps=0
M1236 a_1970_621# C4 vdd w_1964_608# CMOSP w=40 l=2
+  ad=0 pd=0 as=0 ps=0
M1237 vdd a_227_1501# a_383_1480# w_377_1467# CMOSP w=40 l=2
+  ad=0 pd=0 as=0 ps=0
M1238 vdd a_2025_1400# a_2181_1379# w_2175_1366# CMOSP w=40 l=2
+  ad=0 pd=0 as=0 ps=0
M1239 vdd a_951_853# C4 w_971_624# CMOSP w=40 l=2
+  ad=0 pd=0 as=0 ps=0
M1240 a_2221_1927# cin vdd w_2215_1914# CMOSP w=40 l=2
+  ad=0 pd=0 as=0 ps=0
M1241 vdd a_636_1848# a_792_1827# w_786_1814# CMOSP w=40 l=2
+  ad=0 pd=0 as=0 ps=0
M1242 vdd B0 a_647_1760# w_641_1747# CMOSP w=40 l=2
+  ad=0 pd=0 as=0 ps=0
M1243 a_394_162# A4 a_336_162# Gnd CMOSN w=40 l=2
+  ad=0 pd=0 as=200 ps=90
M1244 a_2059_1008# a_545_659# gnd Gnd CMOSN w=40 l=2
+  ad=0 pd=0 as=0 ps=0
M1245 a_386_844# a_332_1025# gnd Gnd CMOSN w=20 l=2
+  ad=100 pd=50 as=0 ps=0
M1246 a_1149_9# a_545_659# vdd w_1171_350# CMOSP w=40 l=2
+  ad=0 pd=0 as=0 ps=0
M1247 vdd A3 a_379_696# w_373_683# CMOSP w=40 l=2
+  ad=0 pd=0 as=0 ps=0
M1248 vdd B3 a_322_397# w_318_489# CMOSP w=40 l=2
+  ad=0 pd=0 as=0 ps=0
M1249 a_2221_2013# a_2065_1948# vdd w_2215_2000# CMOSP w=40 l=2
+  ad=0 pd=0 as=0 ps=0
M1250 vdd a_2160_1073# S4 w_2320_1023# CMOSP w=40 l=2
+  ad=0 pd=0 as=0 ps=0
M1251 vdd a_1970_621# a_2126_600# w_2120_587# CMOSP w=40 l=2
+  ad=0 pd=0 as=0 ps=0
M1252 a_589_279# a_368_230# gnd Gnd CMOSN w=40 l=2
+  ad=0 pd=0 as=0 ps=0
M1253 a_1504_419# a_545_659# a_1504_411# Gnd CMOSN w=100 l=2
+  ad=0 pd=0 as=0 ps=0
M1254 a_1157_9# a_698_1711# vdd w_1440_382# CMOSP w=40 l=2
+  ad=0 pd=0 as=0 ps=0
M1255 a_398_1343# a_382_1341# vdd w_392_1330# CMOSP w=40 l=2
+  ad=200 pd=90 as=0 ps=0
M1256 a_2295_1698# a_549_1529# gnd Gnd CMOSN w=40 l=2
+  ad=0 pd=0 as=0 ps=0
M1257 gnd B3 a_382_502# Gnd CMOSN w=40 l=2
+  ad=0 pd=0 as=0 ps=0
M1258 a_446_1407# B1 a_382_1341# Gnd CMOSN w=40 l=2
+  ad=0 pd=0 as=200 ps=90
M1259 a_379_610# a_223_631# a_434_610# Gnd CMOSN w=40 l=2
+  ad=200 pd=90 as=0 ps=0
M1260 a_2065_1948# a_958_1876# a_2120_1948# Gnd CMOSN w=40 l=2
+  ad=200 pd=90 as=0 ps=0
M1261 a_2065_1948# cin vdd w_2059_1935# CMOSP w=40 l=2
+  ad=0 pd=0 as=0 ps=0
M1262 a_419_1110# B2 gnd Gnd CMOSN w=40 l=2
+  ad=0 pd=0 as=0 ps=0
M1263 a_2381_1036# a_2160_987# gnd Gnd CMOSN w=40 l=2
+  ad=0 pd=0 as=0 ps=0
M1264 vdd a_800_1767# C1 w_814_1748# CMOSP w=40 l=2
+  ad=0 pd=0 as=0 ps=0
M1265 a_2160_987# a_545_659# vdd w_2154_974# CMOSP w=40 l=2
+  ad=0 pd=0 as=0 ps=0
M1266 vdd A4 a_368_316# w_362_303# CMOSP w=40 l=2
+  ad=0 pd=0 as=0 ps=0
M1267 gnd a_534_279# a_1235_379# Gnd CMOSN w=80 l=2
+  ad=0 pd=0 as=0 ps=0
M1268 a_227_1501# B1 vdd w_221_1488# CMOSP w=40 l=2
+  ad=0 pd=0 as=0 ps=0
M1269 a_278_631# B3 gnd Gnd CMOSN w=40 l=2
+  ad=0 pd=0 as=0 ps=0
M1270 a_2442_1976# a_2221_1927# gnd Gnd CMOSN w=40 l=2
+  ad=0 pd=0 as=0 ps=0
M1271 vdd a_806_1390# C2 w_787_1466# CMOSP w=40 l=2
+  ad=0 pd=0 as=0 ps=0
M1272 a_2025_1400# a_530_1159# vdd w_2019_1387# CMOSP w=40 l=2
+  ad=0 pd=0 as=0 ps=0
M1273 a_791_1307# a_398_1343# a_733_1307# Gnd CMOSN w=40 l=2
+  ad=0 pd=0 as=200 ps=90
M1274 a_636_1848# B0 vdd w_630_1835# CMOSP w=40 l=2
+  ad=0 pd=0 as=0 ps=0
M1275 vdd a_958_1876# a_800_1767# w_979_1769# CMOSP w=40 l=2
+  ad=0 pd=0 as=0 ps=0
M1276 gnd a_1157_9# a_1151_13# Gnd CMOSN w=100 l=2
+  ad=0 pd=0 as=0 ps=0
M1277 a_438_1566# a_227_1501# gnd Gnd CMOSN w=40 l=2
+  ad=0 pd=0 as=0 ps=0
M1278 a_2236_1465# a_2025_1400# gnd Gnd CMOSN w=40 l=2
+  ad=0 pd=0 as=0 ps=0
M1279 a_364_1110# B2 vdd w_358_1097# CMOSP w=40 l=2
+  ad=0 pd=0 as=0 ps=0
M1280 vdd a_733_1307# C3 w_1308_1038# CMOSP w=40 l=2
+  ad=0 pd=0 as=0 ps=0
M1281 a_847_1913# a_636_1848# gnd Gnd CMOSN w=40 l=2
+  ad=0 pd=0 as=0 ps=0
M1282 a_1321_946# a_332_1025# C3 Gnd CMOSN w=80 l=2
+  ad=0 pd=0 as=400 ps=170
M1283 a_1225_857# a_698_1711# a_998_529# Gnd CMOSN w=80 l=2
+  ad=0 pd=0 as=400 ps=170
M1284 a_368_230# a_212_251# a_423_230# Gnd CMOSN w=40 l=2
+  ad=200 pd=90 as=0 ps=0
M1285 a_1149_9# a_530_1159# vdd w_1171_350# CMOSP w=40 l=2
+  ad=0 pd=0 as=0 ps=0
M1286 a_1232_1360# a_958_1876# a_1232_1352# Gnd CMOSN w=80 l=2
+  ad=0 pd=0 as=0 ps=0
M1287 a_922_1342# a_530_1159# vdd w_916_1329# CMOSP w=40 l=2
+  ad=0 pd=0 as=0 ps=0
M1288 C5 a_336_162# vdd w_1114_125# CMOSP w=40 l=2
+  ad=0 pd=0 as=0 ps=0
M1289 S5 a_2126_600# vdd w_2286_636# CMOSP w=40 l=2
+  ad=0 pd=0 as=0 ps=0
M1290 a_2126_686# a_1970_621# vdd w_2120_673# CMOSP w=40 l=2
+  ad=0 pd=0 as=0 ps=0
M1291 a_2221_2013# a_958_1876# a_2276_2013# Gnd CMOSN w=40 l=2
+  ad=200 pd=90 as=0 ps=0
M1292 a_1061_1622# a_958_1876# a_1061_1614# Gnd CMOSN w=60 l=2
+  ad=0 pd=0 as=0 ps=0
M1293 a_383_1566# a_227_1501# vdd w_377_1553# CMOSP w=40 l=2
+  ad=0 pd=0 as=0 ps=0
M1294 a_2181_1465# a_2025_1400# vdd w_2175_1452# CMOSP w=40 l=2
+  ad=0 pd=0 as=0 ps=0
M1295 gnd A2 a_390_1025# Gnd CMOSN w=40 l=2
+  ad=0 pd=0 as=0 ps=0
M1296 a_1504_403# a_549_1529# a_1504_395# Gnd CMOSN w=100 l=2
+  ad=0 pd=0 as=0 ps=0
M1297 a_792_1913# a_636_1848# vdd w_786_1900# CMOSP w=40 l=2
+  ad=0 pd=0 as=0 ps=0
M1298 a_1043_1782# cin a_800_1767# Gnd CMOSN w=40 l=2
+  ad=0 pd=0 as=200 ps=90
M1299 a_604_1529# a_383_1480# gnd Gnd CMOSN w=40 l=2
+  ad=0 pd=0 as=0 ps=0
M1300 a_2402_1428# a_2181_1379# gnd Gnd CMOSN w=40 l=2
+  ad=0 pd=0 as=0 ps=0
M1301 a_267_251# B4 gnd Gnd CMOSN w=40 l=2
+  ad=0 pd=0 as=0 ps=0
C0 a_636_1848# a_792_1827# 0.08fF
C1 a_379_696# a_379_610# 0.23fF
C2 gnd a_534_279# 0.34fF
C3 w_2078_1706# a_2084_1719# 0.02fF
C4 gnd a_2025_1400# 0.01fF
C5 a_534_279# C4 0.32fF
C6 a_322_397# B3 0.08fF
C7 gnd a_2025_621# 0.41fF
C8 w_787_1466# a_814_1390# 0.08fF
C9 w_2154_974# a_2160_987# 0.02fF
C10 a_792_1827# a_847_1827# 0.47fF
C11 gnd a_1504_419# 0.86fF
C12 a_534_279# a_338_399# 1.02fF
C13 gnd a_2240_1698# 0.02fF
C14 vdd a_636_1848# 1.39fF
C15 S1 a_2442_1976# 0.47fF
C16 C2 a_800_1394# 0.65fF
C17 w_945_840# vdd 0.11fF
C18 w_787_1466# vdd 0.11fF
C19 gnd a_724_379# 0.07fF
C20 a_212_251# gnd 0.01fF
C21 w_2120_673# vdd 0.14fF
C22 gnd a_791_1307# 0.45fF
C23 a_922_1342# C3 0.08fF
C24 a_336_162# gnd 0.17fF
C25 w_911_370# vdd 0.11fF
C26 gnd S3 0.01fF
C27 w_330_149# vdd 0.15fF
C28 a_549_1529# a_922_1342# 0.20fF
C29 w_641_1747# a_647_1760# 0.02fF
C30 a_814_1390# a_1061_1614# 0.65fF
C31 a_1157_9# a_1149_9# 0.21fF
C32 a_338_399# a_724_379# 0.08fF
C33 w_358_1183# a_364_1196# 0.02fF
C34 w_202_1118# A2 0.08fF
C35 C2 a_530_1159# 0.22fF
C36 a_212_251# a_368_230# 0.08fF
C37 gnd a_2004_1008# 0.01fF
C38 w_945_840# a_951_853# 0.09fF
C39 a_1149_9# a_1235_363# 0.85fF
C40 a_1235_379# a_1235_371# 0.82fF
C41 w_1161_844# a_998_529# 0.05fF
C42 w_1308_1038# C3 0.05fF
C43 a_423_316# a_368_316# 0.47fF
C44 C5 a_724_379# 0.08fF
C45 a_958_1876# a_2065_1948# 1.53fF
C46 a_733_1307# a_332_1025# 0.20fF
C47 gnd a_698_1711# 0.74fF
C48 w_2175_1366# a_530_1159# 0.08fF
C49 a_336_162# C5 0.08fF
C50 w_217_618# a_223_631# 0.02fF
C51 w_539_646# a_379_696# 0.08fF
C52 a_698_1711# C4 0.01fF
C53 a_800_1767# a_1043_1782# 0.44fF
C54 vdd a_2084_1719# 1.39fF
C55 w_2175_1452# a_2025_1400# 0.08fF
C56 a_1135_13# a_1143_13# 1.03fF
C57 w_2019_1387# C2 0.08fF
C58 w_2120_673# a_2126_686# 0.02fF
C59 w_971_624# a_322_397# 0.08fF
C60 w_1964_608# a_534_279# 0.08fF
C61 C3 a_2160_1073# 0.08fF
C62 w_1171_350# a_534_279# 0.08fF
C63 w_971_624# C4 0.05fF
C64 w_692_1698# a_698_1711# 0.06fF
C65 gnd a_691_1848# 0.41fF
C66 gnd a_2381_1036# 0.41fF
C67 w_2234_1771# C1 0.08fF
C68 w_979_1769# vdd 0.15fF
C69 a_530_1159# a_398_1343# 2.70fF
C70 a_1174_1352# a_1232_1360# 0.03fF
C71 a_2221_2013# a_2221_1927# 0.23fF
C72 a_383_1566# a_383_1480# 0.23fF
C73 B0 a_647_1760# 0.08fF
C74 gnd a_874_1613# 0.45fF
C75 A0 a_792_1913# 0.08fF
C76 w_1440_382# a_1157_9# 0.11fF
C77 w_718_366# a_338_399# 0.08fF
C78 w_392_1330# a_382_1341# 0.08fF
C79 a_545_659# a_379_696# 0.08fF
C80 w_727_1294# vdd 0.15fF
C81 w_1998_995# a_2004_1008# 0.02fF
C82 a_2240_1784# S2 0.08fF
C83 w_380_831# a_332_1025# 0.08fF
C84 vdd a_1157_9# 3.22fF
C85 vdd S2 0.88fF
C86 a_2065_1948# gnd 0.01fF
C87 w_1114_125# a_724_379# 0.08fF
C88 B4 w_206_238# 0.08fF
C89 a_368_230# w_362_217# 0.02fF
C90 a_998_529# a_1225_857# 0.85fF
C91 a_549_1529# a_530_1159# 2.68fF
C92 a_951_853# a_1009_853# 0.65fF
C93 w_2059_1935# a_2065_1948# 0.02fF
C94 w_2381_1963# a_2221_2013# 0.08fF
C95 vdd a_733_1307# 1.05fF
C96 gnd a_383_1480# 0.02fF
C97 w_641_1747# vdd 0.15fF
C98 a_2181_1379# a_2236_1379# 0.47fF
C99 a_336_162# w_1114_125# 0.08fF
C100 gnd a_386_844# 0.37fF
C101 A3 a_379_696# 0.08fF
C102 w_810_1600# a_698_1711# 0.08fF
C103 gnd a_922_1342# 0.06fF
C104 w_786_1900# vdd 0.14fF
C105 a_398_1343# a_545_659# 1.26fF
C106 w_1161_844# a_698_1711# 0.08fF
C107 gnd a_223_631# 0.01fF
C108 w_2320_1023# a_2160_987# 0.08fF
C109 a_958_1876# a_792_1913# 0.08fF
C110 a_2065_1948# a_2120_1948# 0.47fF
C111 gnd a_379_610# 0.02fF
C112 a_2181_1465# a_2236_1465# 0.47fF
C113 C3 a_545_659# 0.22fF
C114 gnd a_2347_649# 0.41fF
C115 a_1970_621# a_2126_600# 0.08fF
C116 gnd a_382_502# 0.45fF
C117 gnd a_878_1761# 0.45fF
C118 a_322_397# a_382_502# 0.44fF
C119 a_549_1529# a_545_659# 0.24fF
C120 w_380_831# vdd 0.08fF
C121 a_958_1876# a_530_1159# 0.23fF
C122 w_543_1516# vdd 0.14fF
C123 a_534_279# a_724_379# 0.17fF
C124 gnd a_975_391# 0.65fF
C125 w_373_597# vdd 0.14fF
C126 gnd a_980_1342# 0.03fF
C127 w_2381_1963# S1 0.02fF
C128 a_647_1760# a_705_1760# 0.44fF
C129 gnd a_1235_371# 0.04fF
C130 a_267_251# gnd 0.41fF
C131 w_332_386# vdd 0.08fF
C132 gnd a_364_1110# 0.02fF
C133 a_1157_9# a_1504_411# 0.03fF
C134 w_979_1769# cin 0.08fF
C135 gnd a_800_1394# 0.03fF
C136 a_1143_13# gnd 0.03fF
C137 vdd B0 0.66fF
C138 w_528_266# vdd 0.14fF
C139 vdd a_2160_987# 1.12fF
C140 a_814_1390# a_806_1390# 0.21fF
C141 w_377_1553# a_227_1501# 0.08fF
C142 a_958_1876# a_2221_2013# 0.08fF
C143 a_975_391# a_975_383# 0.62fF
C144 w_524_1146# a_364_1110# 0.08fF
C145 a_698_1711# a_998_529# 0.14fF
C146 gnd a_2139_1719# 0.41fF
C147 vdd a_806_1390# 1.05fF
C148 w_1168_1339# a_530_1159# 0.08fF
C149 a_398_1343# a_1149_9# 0.08fF
C150 a_1149_9# a_1235_379# 0.03fF
C151 w_326_1012# a_332_1025# 0.02fF
C152 a_336_162# a_724_379# 0.21fF
C153 a_212_251# A4 1.53fF
C154 a_958_1876# a_800_1767# 0.17fF
C155 w_2175_1452# a_2181_1465# 0.02fF
C156 w_971_624# a_998_529# 0.08fF
C157 a_364_1196# a_364_1110# 0.23fF
C158 a_398_1343# a_332_1025# 0.07fF
C159 A0 a_647_1760# 0.08fF
C160 a_336_162# A4 0.08fF
C161 a_698_1711# a_534_279# 0.09fF
C162 w_217_618# A3 0.08fF
C163 w_2234_1685# a_2240_1698# 0.02fF
C164 w_2078_1706# a_549_1529# 0.08fF
C165 a_814_1390# C2 0.08fF
C166 w_373_683# a_379_696# 0.02fF
C167 gnd a_530_1159# 0.55fF
C168 a_364_1110# a_419_1110# 0.47fF
C169 C5 a_1143_13# 0.03fF
C170 a_1127_13# a_1135_13# 1.03fF
C171 a_530_1159# C4 0.08fF
C172 a_332_1025# C3 0.08fF
C173 vdd C2 1.62fF
C174 w_2120_587# a_1970_621# 0.08fF
C175 w_718_366# a_534_279# 0.08fF
C176 w_318_489# a_322_397# 0.02fF
C177 w_524_1146# a_530_1159# 0.02fF
C178 w_2286_636# a_2126_600# 0.08fF
C179 a_549_1529# a_332_1025# 2.29fF
C180 vdd a_379_696# 1.68fF
C181 gnd S4 0.01fF
C182 w_2175_1366# vdd 0.14fF
C183 w_814_1748# C1 0.02fF
C184 w_2154_1060# a_2004_1008# 0.08fF
C185 vdd a_2221_1927# 1.12fF
C186 a_530_1159# a_364_1196# 0.08fF
C187 vdd a_2126_600# 1.12fF
C188 a_227_1501# a_282_1501# 0.47fF
C189 w_2215_2000# a_2065_1948# 0.08fF
C190 C1 a_878_1761# 0.44fF
C191 gnd a_800_1767# 0.07fF
C192 w_718_366# a_724_379# 0.02fF
C193 a_545_659# a_322_397# 0.06fF
C194 gnd a_545_659# 0.59fF
C195 w_786_1900# a_636_1848# 0.08fF
C196 w_326_1012# vdd 0.15fF
C197 a_2160_1073# a_2215_1073# 0.47fF
C198 w_997_1601# a_549_1529# 0.08fF
C199 a_212_251# w_362_217# 0.08fF
C200 w_2381_1963# vdd 0.14fF
C201 vdd a_398_1343# 0.83fF
C202 gnd a_1232_1368# 0.87fF
C203 gnd a_227_1501# 0.01fF
C204 w_528_266# a_368_316# 0.08fF
C205 a_792_1913# a_847_1913# 0.47fF
C206 B4 vdd 0.47fF
C207 a_332_1025# a_390_1025# 0.44fF
C208 gnd a_438_1480# 0.41fF
C209 gnd a_1009_861# 0.65fF
C210 w_786_1814# a_792_1827# 0.02fF
C211 vdd C3 2.05fF
C212 a_549_1529# a_814_1390# 0.14fF
C213 w_1440_382# a_549_1529# 0.08fF
C214 A3 a_322_397# 0.08fF
C215 a_1174_1352# C3 0.08fF
C216 w_1161_844# a_530_1159# 0.08fF
C217 vdd a_549_1529# 2.43fF
C218 vdd A0 0.45fF
C219 a_2126_686# a_2181_686# 0.47fF
C220 a_223_631# B3 0.23fF
C221 gnd a_1970_621# 0.01fF
C222 w_2341_1415# S3 0.02fF
C223 C3 a_1329_946# 0.03fF
C224 a_2126_686# a_2126_600# 0.23fF
C225 gnd S5 0.01fF
C226 a_1970_621# C4 0.23fF
C227 a_549_1529# a_1174_1352# 0.08fF
C228 w_2215_1914# a_2065_1948# 0.08fF
C229 w_952_1863# a_958_1876# 0.02fF
C230 w_786_1814# vdd 0.14fF
C231 a_398_1343# a_951_853# 0.08fF
C232 w_1171_350# a_530_1159# 0.08fF
C233 a_386_844# a_724_379# 0.10fF
C234 a_636_1848# B0 0.23fF
C235 gnd a_647_1760# 0.26fF
C236 gnd a_1000_532# 0.87fF
C237 a_398_1343# a_749_843# 0.07fF
C238 w_1998_995# a_545_659# 0.08fF
C239 cin C2 0.10fF
C240 w_997_1601# a_958_1876# 0.08fF
C241 w_377_1553# vdd 0.14fF
C242 C4 a_1000_532# 0.03fF
C243 gnd a_917_383# 0.06fF
C244 a_2181_1465# S3 0.08fF
C245 a_958_1876# a_792_1827# 0.08fF
C246 a_336_162# a_386_844# 0.10fF
C247 w_217_618# vdd 0.14fF
C248 a_814_1390# a_1061_1622# 0.03fF
C249 a_992_532# a_1000_532# 0.82fF
C250 w_916_1329# a_549_1529# 0.08fF
C251 w_787_1466# a_806_1390# 0.08fF
C252 a_589_279# gnd 0.41fF
C253 w_2120_587# vdd 0.14fF
C254 w_692_1698# a_647_1760# 0.08fF
C255 gnd a_208_1131# 0.01fF
C256 a_958_1876# a_814_1390# 0.17fF
C257 a_1127_13# gnd 0.03fF
C258 w_2175_1366# a_2181_1379# 0.02fF
C259 w_362_303# vdd 0.14fF
C260 gnd a_332_1025# 0.18fF
C261 w_1161_844# a_545_659# 0.08fF
C262 a_1504_411# a_1504_403# 1.03fF
C263 a_1157_9# a_1504_395# 1.06fF
C264 w_382_1394# vdd 0.15fF
C265 w_727_1294# a_733_1307# 0.02fF
C266 vdd a_958_1876# 1.75fF
C267 w_377_1553# A1 0.08fF
C268 a_917_383# a_975_383# 0.65fF
C269 w_326_1012# A2 0.08fF
C270 w_377_1467# a_383_1480# 0.02fF
C271 w_1171_350# a_545_659# 0.08fF
C272 w_2400_1734# a_2240_1698# 0.08fF
C273 a_958_1876# a_1174_1352# 0.08fF
C274 gnd a_2402_1428# 0.41fF
C275 a_530_1159# a_998_529# 0.20fF
C276 C1 a_800_1767# 0.08fF
C277 C5 a_917_383# 0.08fF
C278 w_787_1466# C2 0.09fF
C279 a_212_251# a_267_251# 0.47fF
C280 a_698_1711# a_922_1342# 0.08fF
C281 w_743_830# a_386_844# 0.08fF
C282 C5 a_1149_9# 0.08fF
C283 w_382_1394# A1 0.08fF
C284 a_530_1159# a_534_279# 0.08fF
C285 vdd a_383_1566# 1.68fF
C286 gnd a_792_1827# 0.02fF
C287 w_382_1394# B1 0.08fF
C288 C5 a_1127_13# 1.06fF
C289 a_2025_1400# a_530_1159# 0.23fF
C290 a_1329_946# a_1337_946# 0.82fF
C291 a_2160_987# a_2215_987# 0.47fF
C292 w_2154_1060# a_2160_1073# 0.02fF
C293 w_1168_1339# vdd 0.18fF
C294 a_2221_2013# a_2276_2013# 0.47fF
C295 w_1964_608# a_1970_621# 0.02fF
C296 gnd a_814_1390# 0.06fF
C297 cin a_549_1529# 0.09fF
C298 w_1168_1339# a_1174_1352# 0.05fF
C299 w_318_489# B3 0.08fF
C300 w_2215_2000# a_2221_2013# 0.02fF
C301 vdd a_322_397# 1.55fF
C302 w_2019_1387# a_2025_1400# 0.02fF
C303 w_2341_1415# a_2181_1465# 0.08fF
C304 vdd gnd 17.51fF
C305 a_545_659# a_998_529# 0.10fF
C306 A1 a_383_1566# 0.08fF
C307 w_945_840# a_398_1343# 0.08fF
C308 vdd C4 2.16fF
C309 gnd a_1174_1352# 0.04fF
C310 w_2059_1935# vdd 0.14fF
C311 C1 a_647_1760# 0.08fF
C312 a_545_659# a_534_279# 2.39fF
C313 gnd a_1329_946# 0.04fF
C314 w_2078_1706# C1 0.08fF
C315 w_524_1146# vdd 0.14fF
C316 w_692_1698# vdd 0.08fF
C317 vdd a_338_399# 0.54fF
C318 w_1114_125# a_917_383# 0.08fF
C319 a_1174_1352# a_1232_1352# 0.85fF
C320 w_1171_350# a_1149_9# 0.05fF
C321 a_212_251# w_206_238# 0.02fF
C322 w_641_1747# B0 0.08fF
C323 w_362_303# a_368_316# 0.02fF
C324 w_206_238# A4 0.08fF
C325 w_1114_125# a_1149_9# 0.08fF
C326 A0 a_636_1848# 1.53fF
C327 a_368_230# vdd 1.12fF
C328 B4 w_330_149# 0.08fF
C329 vdd a_364_1196# 1.68fF
C330 w_2154_974# a_2004_1008# 0.08fF
C331 a_958_1876# cin 1.27fF
C332 a_749_843# a_807_843# 0.44fF
C333 C5 vdd 2.14fF
C334 gnd a_951_853# 0.06fF
C335 w_786_1814# a_636_1848# 0.08fF
C336 a_951_853# C4 0.08fF
C337 a_379_696# a_434_696# 0.47fF
C338 gnd a_749_843# 0.07fF
C339 a_698_1711# a_530_1159# 2.62fF
C340 gnd a_2295_1784# 0.41fF
C341 A3 B3 1.03fF
C342 a_534_279# a_1970_621# 1.53fF
C343 a_749_843# C4 0.08fF
C344 a_223_631# a_379_610# 0.08fF
C345 w_1998_995# vdd 0.14fF
C346 gnd a_278_631# 0.41fF
C347 w_630_1835# vdd 0.14fF
C348 gnd a_980_1350# 0.65fF
C349 w_1308_1038# a_922_1342# 0.08fF
C350 a_1970_621# a_2025_621# 0.47fF
C351 gnd a_984_532# 0.04fF
C352 w_1168_1339# cin 0.08fF
C353 w_810_1600# vdd 0.15fF
C354 C4 a_984_532# 0.85fF
C355 a_534_279# a_917_383# 0.08fF
C356 gnd a_1504_411# 0.03fF
C357 a_922_1342# a_980_1342# 0.65fF
C358 C2 a_808_1394# 0.03fF
C359 w_1161_844# vdd 0.18fF
C360 a_2004_1008# a_545_659# 0.23fF
C361 w_2175_1452# vdd 0.14fF
C362 gnd a_782_379# 0.45fF
C363 a_984_532# a_992_532# 0.82fF
C364 a_423_316# gnd 0.41fF
C365 a_589_279# a_534_279# 0.47fF
C366 w_1964_608# vdd 0.14fF
C367 a_549_1529# a_604_1529# 0.47fF
C368 a_2084_1719# a_549_1529# 0.23fF
C369 gnd a_368_316# 0.00fF
C370 a_698_1711# a_545_659# 0.03fF
C371 gnd cin 0.33fF
C372 a_394_162# gnd 0.45fF
C373 w_1171_350# vdd 0.18fF
C374 gnd a_263_1131# 0.41fF
C375 S4 a_2381_1036# 0.47fF
C376 gnd a_2181_1379# 0.02fF
C377 w_743_830# a_545_659# 0.08fF
C378 a_1157_9# a_1504_403# 0.03fF
C379 w_727_1294# a_398_1343# 0.08fF
C380 C1 a_2240_1784# 0.08fF
C381 vdd C1 1.20fF
C382 w_1114_125# vdd 0.14fF
C383 a_1061_1622# a_1061_1614# 0.62fF
C384 w_2059_1935# cin 0.08fF
C385 a_917_383# a_724_379# 0.34fF
C386 a_1504_403# a_1504_395# 1.03fF
C387 w_358_1183# a_208_1131# 0.08fF
C388 w_377_1467# a_227_1501# 0.08fF
C389 a_398_1343# a_733_1307# 0.08fF
C390 w_358_1097# B2 0.08fF
C391 a_2221_1927# a_2276_1927# 0.47fF
C392 A2 a_364_1196# 0.08fF
C393 a_368_230# a_368_316# 0.23fF
C394 a_530_1159# a_922_1342# 0.31fF
C395 a_549_1529# a_1157_9# 0.08fF
C396 a_733_1307# C3 0.08fF
C397 a_208_1131# B2 0.23fF
C398 gnd a_2295_1698# 0.41fF
C399 gnd a_636_1848# 0.01fF
C400 a_1321_946# a_1329_946# 0.82fF
C401 w_392_1330# vdd 0.08fF
C402 vdd a_382_1341# 1.59fF
C403 B2 a_332_1025# 0.08fF
C404 a_549_1529# a_733_1307# 0.24fF
C405 vdd a_998_529# 1.81fF
C406 w_539_646# a_379_610# 0.08fF
C407 w_641_1747# A0 0.08fF
C408 a_647_1760# a_698_1711# 0.08fF
C409 w_1440_382# a_534_279# 0.08fF
C410 a_806_1390# C2 0.08fF
C411 gnd a_2236_1379# 0.41fF
C412 w_2215_2000# vdd 0.14fF
C413 gnd a_847_1827# 0.41fF
C414 S3 a_2402_1428# 0.47fF
C415 vdd a_534_279# 2.39fF
C416 w_2234_1771# a_2240_1784# 0.02fF
C417 w_786_1900# A0 0.08fF
C418 vdd a_2025_1400# 1.39fF
C419 w_2234_1771# vdd 0.14fF
C420 w_979_1769# a_958_1876# 0.08fF
C421 vdd B3 0.47fF
C422 a_545_659# a_386_844# 0.68fF
C423 A1 a_382_1341# 0.08fF
C424 a_227_1501# a_383_1480# 0.08fF
C425 gnd a_1061_1614# 0.03fF
C426 a_698_1711# a_332_1025# 0.19fF
C427 a_382_1341# B1 0.08fF
C428 a_383_1480# a_438_1480# 0.47fF
C429 w_358_1183# vdd 0.14fF
C430 w_814_1748# a_800_1767# 0.08fF
C431 a_2240_1784# a_2240_1698# 0.23fF
C432 vdd a_2240_1698# 1.12fF
C433 a_998_529# a_951_853# 0.32fF
C434 vdd a_724_379# 1.05fF
C435 a_212_251# vdd 1.39fF
C436 w_543_1516# a_549_1529# 0.02fF
C437 vdd A4 0.45fF
C438 gnd a_604_1529# 0.41fF
C439 gnd a_2084_1719# 0.01fF
C440 cin C1 0.22fF
C441 a_336_162# vdd 1.03fF
C442 gnd a_2215_987# 0.41fF
C443 w_630_1835# a_636_1848# 0.02fF
C444 w_2154_1060# vdd 0.14fF
C445 vdd B2 0.47fF
C446 a_2160_1073# S4 0.08fF
C447 vdd S3 0.88fF
C448 A3 a_223_631# 1.53fF
C449 gnd a_1009_853# 0.03fF
C450 w_2215_1914# vdd 0.14fF
C451 gnd a_1232_1360# 0.04fF
C452 A0 B0 0.69fF
C453 a_534_279# a_2126_686# 0.08fF
C454 gnd a_434_696# 0.41fF
C455 w_2234_1685# vdd 0.14fF
C456 a_1232_1360# a_1232_1352# 0.82fF
C457 gnd a_600_659# 0.41fF
C458 w_786_1814# B0 0.08fF
C459 vdd a_2004_1008# 1.39fF
C460 a_549_1529# a_806_1390# 0.17fF
C461 a_386_844# a_917_383# 0.08fF
C462 gnd a_434_610# 0.41fF
C463 w_1440_382# a_698_1711# 0.08fF
C464 w_814_1748# a_647_1760# 0.08fF
C465 vdd a_698_1711# 1.07fF
C466 S5 a_2347_649# 0.47fF
C467 gnd a_1157_9# 0.05fF
C468 gnd S2 0.01fF
C469 w_2019_1387# a_530_1159# 0.08fF
C470 gnd a_2442_1976# 0.41fF
C471 w_743_830# vdd 0.15fF
C472 w_377_1467# vdd 0.14fF
C473 a_2126_600# a_2181_600# 0.47fF
C474 gnd a_1504_395# 0.03fF
C475 w_971_624# vdd 0.18fF
C476 a_332_1025# a_386_844# 0.08fF
C477 gnd a_733_1307# 0.07fF
C478 w_2381_1963# a_2221_1927# 0.08fF
C479 a_534_279# a_368_316# 0.08fF
C480 gnd a_1235_363# 0.04fF
C481 a_423_230# gnd 0.41fF
C482 w_718_366# vdd 0.15fF
C483 gnd a_585_1159# 0.41fF
C484 w_2154_974# a_545_659# 0.08fF
C485 gnd a_808_1394# 0.65fF
C486 a_1504_419# a_1504_411# 1.03fF
C487 a_530_1159# a_545_659# 3.51fF
C488 a_2025_1400# a_2181_1379# 0.08fF
C489 a_1151_13# gnd 0.86fF
C490 w_362_217# vdd 0.14fF
C491 w_539_646# a_545_659# 0.02fF
C492 a_917_383# a_975_391# 0.03fF
C493 w_358_1183# A2 0.08fF
C494 w_221_1488# a_227_1501# 0.02fF
C495 w_543_1516# a_383_1566# 0.08fF
C496 w_916_1329# a_698_1711# 0.08fF
C497 a_724_379# a_782_379# 0.44fF
C498 S2 a_2461_1747# 0.47fF
C499 w_358_1097# a_364_1110# 0.02fF
C500 w_202_1118# B2 0.08fF
C501 C5 a_1157_9# 0.08fF
C502 gnd a_2276_1927# 0.41fF
C503 w_787_1466# a_382_1341# 0.08fF
C504 w_377_1467# B1 0.08fF
C505 a_1149_9# a_1235_371# 0.03fF
C506 w_2341_1415# vdd 0.14fF
C507 w_1308_1038# a_332_1025# 0.08fF
C508 a_368_230# a_423_230# 0.47fF
C509 vdd a_2065_1948# 1.39fF
C510 w_743_830# a_749_843# 0.02fF
C511 w_971_624# a_951_853# 0.08fF
C512 A4 a_368_316# 0.08fF
C513 a_208_1131# a_364_1110# 0.08fF
C514 A2 B2 0.84fF
C515 a_336_162# a_394_162# 0.44fF
C516 w_373_683# a_223_631# 0.08fF
C517 w_971_624# a_749_843# 0.08fF
C518 gnd a_2080_1400# 0.41fF
C519 C1 a_2084_1719# 1.53fF
C520 vdd a_383_1480# 1.12fF
C521 C5 a_1151_13# 0.03fF
C522 w_2120_673# a_534_279# 0.08fF
C523 w_318_489# A3 0.08fF
C524 a_549_1529# a_398_1343# 0.01fF
C525 w_2215_1914# cin 0.08fF
C526 a_958_1876# C2 0.10fF
C527 vdd a_2181_1465# 1.68fF
C528 vdd a_386_844# 0.90fF
C529 w_332_386# a_322_397# 0.08fF
C530 w_911_370# a_534_279# 0.08fF
C531 a_2240_1698# a_2295_1698# 0.47fF
C532 vdd a_922_1342# 1.49fF
C533 gnd B0 0.10fF
C534 w_2120_587# a_2126_600# 0.02fF
C535 vdd a_223_631# 1.39fF
C536 gnd a_2160_987# 0.02fF
C537 w_2320_1023# a_2160_1073# 0.08fF
C538 w_814_1748# vdd 0.15fF
C539 a_1174_1352# a_922_1342# 0.21fF
C540 vdd a_379_610# 1.12fF
C541 a_2221_2013# S1 0.08fF
C542 a_530_1159# a_1149_9# 0.18fF
C543 a_383_1566# a_438_1566# 0.47fF
C544 gnd a_806_1390# 0.07fF
C545 w_332_386# a_338_399# 0.06fF
C546 a_530_1159# a_332_1025# 0.25fF
C547 gnd a_1043_1782# 0.45fF
C548 w_1114_125# a_1157_9# 0.08fF
C549 gnd a_2059_1008# 0.41fF
C550 w_952_1863# a_792_1913# 0.08fF
C551 w_1308_1038# vdd 0.18fF
C552 w_916_1329# a_922_1342# 0.09fF
C553 a_1225_873# a_1225_865# 0.82fF
C554 a_368_230# w_528_266# 0.08fF
C555 gnd a_438_1566# 0.41fF
C556 a_800_1767# a_647_1760# 0.20fF
C557 w_330_149# A4 0.08fF
C558 w_1308_1038# a_1174_1352# 0.08fF
C559 a_792_1913# a_792_1827# 0.23fF
C560 a_386_844# a_749_843# 0.08fF
C561 a_336_162# w_330_149# 0.02fF
C562 w_2400_1734# a_2240_1784# 0.08fF
C563 vdd a_364_1110# 1.12fF
C564 w_2234_1771# a_2084_1719# 0.08fF
C565 w_2400_1734# vdd 0.14fF
C566 gnd C2 0.06fF
C567 a_545_659# a_917_383# 0.08fF
C568 gnd a_1225_865# 0.04fF
C569 vdd a_2160_1073# 1.68fF
C570 a_545_659# a_1149_9# 0.17fF
C571 w_2320_1023# S4 0.02fF
C572 a_2084_1719# a_2240_1698# 0.08fF
C573 a_958_1876# a_549_1529# 1.41fF
C574 a_922_1342# a_980_1350# 0.03fF
C575 a_2065_1948# cin 0.23fF
C576 gnd a_2181_686# 0.41fF
C577 a_223_631# a_278_631# 0.47fF
C578 vdd a_792_1913# 1.68fF
C579 gnd a_2221_1927# 0.02fF
C580 w_2341_1415# a_2181_1379# 0.08fF
C581 w_630_1835# B0 0.08fF
C582 C3 a_1337_946# 0.03fF
C583 gnd a_2126_600# 0.02fF
C584 w_1440_382# a_530_1159# 0.08fF
C585 a_534_279# a_1157_9# 0.08fF
C586 gnd a_705_1760# 0.45fF
C587 a_636_1848# a_691_1848# 0.47fF
C588 gnd a_2181_600# 0.41fF
C589 w_2154_974# vdd 0.14fF
C590 vdd a_530_1159# 2.76fF
C591 w_221_1488# vdd 0.14fF
C592 gnd a_1504_403# 0.03fF
C593 a_958_1876# a_1013_1876# 0.47fF
C594 a_2181_1465# a_2181_1379# 0.23fF
C595 w_810_1600# a_806_1390# 0.02fF
C596 a_398_1343# a_322_397# 0.07fF
C597 w_539_646# vdd 0.14fF
C598 a_549_1529# a_383_1566# 0.08fF
C599 gnd a_398_1343# 0.76fF
C600 gnd a_1235_379# 0.87fF
C601 w_1168_1339# a_549_1529# 0.08fF
C602 w_318_489# vdd 0.15fF
C603 gnd a_419_1196# 0.41fF
C604 w_2234_1685# a_2084_1719# 0.08fF
C605 a_1157_9# a_1504_419# 0.03fF
C606 gnd a_446_1407# 0.45fF
C607 a_980_1350# a_980_1342# 0.62fF
C608 a_1135_13# gnd 0.03fF
C609 w_206_238# vdd 0.14fF
C610 vdd S4 0.88fF
C611 gnd C3 0.14fF
C612 w_2019_1387# vdd 0.14fF
C613 vdd a_2221_2013# 1.68fF
C614 w_377_1553# a_383_1566# 0.02fF
C615 w_221_1488# A1 0.08fF
C616 a_917_383# a_1149_9# 0.31fF
C617 w_358_1097# a_208_1131# 0.08fF
C618 gnd a_549_1529# 2.14fF
C619 w_916_1329# a_530_1159# 0.08fF
C620 w_221_1488# B1 0.08fF
C621 w_1440_382# a_545_659# 0.08fF
C622 a_549_1529# C4 0.06fF
C623 a_530_1159# a_951_853# 0.20fF
C624 a_733_1307# a_791_1307# 0.44fF
C625 vdd a_800_1767# 1.29fF
C626 w_2175_1452# C2 0.08fF
C627 vdd a_545_659# 2.01fF
C628 a_364_1196# a_419_1196# 0.47fF
C629 w_373_683# A3 0.08fF
C630 vdd a_227_1501# 1.39fF
C631 a_2025_1400# a_2080_1400# 0.47fF
C632 gnd a_1013_1876# 0.41fF
C633 C5 a_1135_13# 0.03fF
C634 w_911_370# a_386_844# 0.08fF
C635 w_1168_1339# a_958_1876# 0.08fF
C636 a_1174_1352# a_1232_1368# 0.03fF
C637 w_373_597# B3 0.08fF
C638 a_806_1390# a_382_1341# 0.21fF
C639 a_698_1711# a_1157_9# 0.08fF
C640 gnd a_1061_1622# 0.65fF
C641 w_528_266# a_534_279# 0.02fF
C642 w_2120_587# C4 0.08fF
C643 vdd A3 0.45fF
C644 w_2286_636# S5 0.02fF
C645 gnd a_390_1025# 0.45fF
C646 w_1998_995# C3 0.08fF
C647 a_958_1876# gnd 0.22fF
C648 vdd S1 0.88fF
C649 vdd a_1970_621# 1.39fF
C650 a_698_1711# a_733_1307# 0.10fF
C651 A1 a_227_1501# 1.53fF
C652 a_545_659# a_951_853# 0.27fF
C653 vdd S5 0.88fF
C654 a_227_1501# B1 0.23fF
C655 a_545_659# a_749_843# 0.27fF
C656 w_2059_1935# a_958_1876# 0.08fF
C657 cin a_530_1159# 0.12fF
C658 vdd a_647_1760# 1.33fF
C659 gnd a_1337_946# 0.87fF
C660 a_382_1341# C2 0.08fF
C661 w_630_1835# A0 0.08fF
C662 w_358_1097# vdd 0.14fF
C663 w_1171_350# a_398_1343# 0.08fF
C664 w_2078_1706# vdd 0.14fF
C665 vdd a_917_383# 1.38fF
C666 a_951_853# a_1009_861# 0.03fF
C667 a_998_529# a_1225_865# 0.03fF
C668 w_810_1600# a_549_1529# 0.08fF
C669 vdd a_1149_9# 1.81fF
C670 w_1161_844# a_549_1529# 0.08fF
C671 a_1225_865# a_1225_857# 0.82fF
C672 vdd a_208_1131# 1.39fF
C673 gnd a_282_1501# 0.41fF
C674 C2 a_2025_1400# 1.53fF
C675 gnd a_1225_873# 0.87fF
C676 vdd a_332_1025# 1.66fF
C677 w_952_1863# a_792_1827# 0.08fF
C678 gnd a_807_843# 0.45fF
C679 w_945_840# a_530_1159# 0.08fF
C680 C1 a_549_1529# 0.22fF
C681 cin a_800_1767# 0.08fF
C682 w_2175_1366# a_2025_1400# 0.08fF
C683 gnd a_322_397# 0.17fF
C684 w_2320_1023# vdd 0.14fF
C685 a_2004_1008# a_2160_987# 0.08fF
C686 C3 a_1321_946# 0.85fF
C687 w_392_1330# a_398_1343# 0.06fF
C688 gnd C4 0.04fF
C689 a_322_397# C4 0.17fF
C690 a_2126_686# S5 0.08fF
C691 w_997_1601# a_814_1390# 0.09fF
C692 gnd a_1232_1352# 0.04fF
C693 w_952_1863# vdd 0.14fF
C694 a_379_610# a_434_610# 0.47fF
C695 gnd a_992_532# 0.04fF
C696 a_382_1341# a_446_1407# 0.44fF
C697 w_997_1601# vdd 0.11fF
C698 gnd a_2236_1465# 0.41fF
C699 gnd a_338_399# 0.33fF
C700 C4 a_992_532# 0.03fF
C701 a_922_1342# a_733_1307# 1.35fF
C702 vdd a_792_1827# 1.12fF
C703 w_373_683# vdd 0.14fF
C704 a_398_1343# a_534_279# 0.01fF
C705 a_2004_1008# a_2059_1008# 0.47fF
C706 a_698_1711# a_806_1390# 0.08fF
C707 gnd a_975_383# 0.03fF
C708 a_368_230# gnd 0.02fF
C709 w_2286_636# vdd 0.14fF
C710 a_2084_1719# a_2139_1719# 0.47fF
C711 a_549_1529# a_998_529# 0.08fF
C712 vdd a_814_1390# 1.39fF
C713 gnd a_2461_1747# 0.41fF
C714 gnd a_2120_1948# 0.41fF
C715 C5 gnd 0.17fF
C716 gnd a_419_1110# 0.41fF
C717 w_1440_382# vdd 0.14fF
C718 w_945_840# a_545_659# 0.08fF
C719 vdd a_2240_1784# 1.68fF
C720 a_958_1876# C1 0.10fF
C721 w_2215_1914# a_2221_1927# 0.02fF
C722 w_524_1146# a_364_1196# 0.08fF
C723 w_1308_1038# a_733_1307# 0.08fF
C724 a_549_1529# a_534_279# 0.18fF
C725 w_202_1118# a_208_1131# 0.02fF
C726 w_543_1516# a_383_1480# 0.08fF
C727 w_2400_1734# S2 0.02fF
C728 w_911_370# a_545_659# 0.08fF
C729 vdd a_1174_1352# 1.87fF
C730 w_326_1012# B2 0.08fF
C731 a_212_251# B4 0.23fF
C732 a_1235_371# a_1235_363# 0.82fF
C733 w_380_831# a_386_844# 0.06fF
C734 a_806_1390# a_874_1613# 0.44fF
C735 A2 a_208_1131# 1.53fF
C736 B4 A4 1.17fF
C737 B4 a_336_162# 0.08fF
C738 A2 a_332_1025# 0.08fF
C739 a_208_1131# a_263_1131# 0.47fF
C740 vdd A1 0.58fF
C741 gnd a_847_1913# 0.41fF
C742 a_800_1394# a_808_1394# 0.62fF
C743 w_382_1394# a_382_1341# 0.02fF
C744 gnd a_2215_1073# 0.41fF
C745 w_373_597# a_223_631# 0.08fF
C746 w_916_1329# vdd 0.11fF
C747 vdd B1 0.47fF
C748 w_2154_1060# C3 0.08fF
C749 a_1143_13# a_1151_13# 1.03fF
C750 w_217_618# B3 0.08fF
C751 w_373_597# a_379_610# 0.02fF
C752 w_2120_673# a_1970_621# 0.08fF
C753 vdd a_951_853# 1.39fF
C754 w_2286_636# a_2126_686# 0.08fF
C755 w_727_1294# a_530_1159# 0.08fF
C756 vdd a_749_843# 0.96fF
C757 w_1964_608# C4 0.08fF
C758 a_530_1159# a_1157_9# 0.08fF
C759 w_2215_2000# a_958_1876# 0.08fF
C760 a_2240_1784# a_2295_1784# 0.47fF
C761 gnd C1 0.07fF
C762 vdd a_2126_686# 1.68fF
C763 a_698_1711# a_398_1343# 0.01fF
C764 w_786_1900# a_792_1913# 0.02fF
C765 C3 a_2004_1008# 1.53fF
C766 a_530_1159# a_733_1307# 0.42fF
C767 A1 B1 0.58fF
C768 w_2234_1685# a_549_1529# 0.08fF
C769 w_997_1601# cin 0.08fF
C770 a_530_1159# a_585_1159# 0.47fF
C771 w_911_370# a_917_383# 0.09fF
C772 gnd a_1321_946# 0.04fF
C773 w_202_1118# vdd 0.14fF
C774 w_979_1769# a_800_1767# 0.02fF
C775 a_1232_1368# a_1232_1360# 0.82fF
C776 a_545_659# a_600_659# 0.47fF
C777 a_2065_1948# a_2221_1927# 0.08fF
C778 a_212_251# w_362_303# 0.08fF
C779 a_998_529# a_1225_873# 0.03fF
C780 C2 a_2181_1465# 0.08fF
C781 a_549_1529# a_698_1711# 3.76fF
C782 w_362_303# A4 0.08fF
C783 cin a_814_1390# 0.08fF
C784 a_1009_861# a_1009_853# 0.62fF
C785 B4 w_362_217# 0.08fF
C786 a_951_853# a_749_843# 0.33fF
C787 vdd A2 0.45fF
C788 gnd a_382_1341# 0.25fF
C789 vdd a_368_316# 1.68fF
C790 vdd cin 1.06fF
C791 a_545_659# a_1157_9# 0.08fF
C792 a_2276_2013# gnd 0.41fF
C793 a_998_529# a_322_397# 0.21fF
C794 C5 w_1114_125# 0.11fF
C795 a_2160_1073# a_2160_987# 0.23fF
C796 vdd a_2181_1379# 1.12fF
C797 a_998_529# C4 0.08fF
C798 gnd a_1225_857# 0.04fF
C799 cin a_1174_1352# 0.18fF
C800 a_1151_13# Gnd 0.01fF
C801 a_1143_13# Gnd 0.01fF
C802 a_1135_13# Gnd 0.01fF
C803 a_1127_13# Gnd 0.01fF
C804 C5 Gnd 6.96fF
C805 a_394_162# Gnd 0.01fF
C806 a_336_162# Gnd 5.36fF
C807 a_423_230# Gnd 0.01fF
C808 a_267_251# Gnd 0.01fF
C809 a_589_279# Gnd 0.01fF
C810 a_368_230# Gnd 0.70fF
C811 a_423_316# Gnd 0.01fF
C812 a_212_251# Gnd 1.30fF
C813 a_368_316# Gnd 0.78fF
C814 a_1235_363# Gnd 0.01fF
C815 a_1235_371# Gnd 0.01fF
C816 a_1235_379# Gnd 0.01fF
C817 a_1149_9# Gnd 3.04fF
C818 a_975_383# Gnd 0.01fF
C819 a_782_379# Gnd 0.01fF
C820 a_724_379# Gnd 6.11fF
C821 a_1504_395# Gnd 0.01fF
C822 a_975_391# Gnd 0.01fF
C823 a_1504_403# Gnd 0.01fF
C824 a_917_383# Gnd 1.56fF
C825 a_338_399# Gnd 1.40fF
C826 a_1504_411# Gnd 0.01fF
C827 a_1504_419# Gnd 0.01fF
C828 a_1157_9# Gnd 2.20fF
C829 a_382_502# Gnd 0.01fF
C830 a_2181_600# Gnd 0.01fF
C831 a_1000_532# Gnd 0.01fF
C832 a_992_532# Gnd 0.01fF
C833 a_984_532# Gnd 0.01fF
C834 a_2025_621# Gnd 0.01fF
C835 a_434_610# Gnd 0.01fF
C836 a_2347_649# Gnd 0.01fF
C837 a_2126_600# Gnd 0.70fF
C838 S5 Gnd 1.82fF
C839 C4 Gnd 4.35fF
C840 a_278_631# Gnd 0.01fF
C841 B3 Gnd 0.06fF
C842 a_600_659# Gnd 0.01fF
C843 a_379_610# Gnd 0.70fF
C844 a_2181_686# Gnd 0.01fF
C845 a_1970_621# Gnd 1.30fF
C846 a_322_397# Gnd 5.92fF
C847 a_2126_686# Gnd 0.78fF
C848 a_534_279# Gnd 16.12fF
C849 a_434_696# Gnd 0.01fF
C850 a_223_631# Gnd 1.30fF
C851 a_379_696# Gnd 0.78fF
C852 A3 Gnd 0.06fF
C853 a_807_843# Gnd 0.01fF
C854 a_749_843# Gnd 3.96fF
C855 a_1225_857# Gnd 0.01fF
C856 a_1009_853# Gnd 0.01fF
C857 a_386_844# Gnd 8.87fF
C858 a_1225_865# Gnd 0.01fF
C859 a_1009_861# Gnd 0.01fF
C860 a_1225_873# Gnd 0.01fF
C861 a_951_853# Gnd 2.14fF
C862 a_998_529# Gnd 4.55fF
C863 a_2215_987# Gnd 0.01fF
C864 a_2059_1008# Gnd 0.01fF
C865 a_545_659# Gnd 13.51fF
C866 a_1337_946# Gnd 0.01fF
C867 a_1329_946# Gnd 0.01fF
C868 a_1321_946# Gnd 0.01fF
C869 a_2381_1036# Gnd 0.01fF
C870 a_2160_987# Gnd 0.70fF
C871 S4 Gnd 1.64fF
C872 a_390_1025# Gnd 0.01fF
C873 a_2215_1073# Gnd 0.01fF
C874 a_2004_1008# Gnd 1.30fF
C875 a_2160_1073# Gnd 0.78fF
C876 C3 Gnd 3.34fF
C877 a_332_1025# Gnd 11.66fF
C878 a_419_1110# Gnd 0.01fF
C879 a_263_1131# Gnd 0.01fF
C880 B2 Gnd 0.06fF
C881 a_585_1159# Gnd 0.01fF
C882 a_364_1110# Gnd 0.70fF
C883 a_419_1196# Gnd 0.01fF
C884 a_208_1131# Gnd 1.30fF
C885 a_364_1196# Gnd 0.78fF
C886 A2 Gnd 0.06fF
C887 a_791_1307# Gnd 0.01fF
C888 a_733_1307# Gnd 7.58fF
C889 a_980_1342# Gnd 0.01fF
C890 a_398_1343# Gnd 4.21fF
C891 a_1232_1352# Gnd 0.01fF
C892 a_980_1350# Gnd 0.01fF
C893 a_1232_1360# Gnd 0.01fF
C894 a_922_1342# Gnd 6.02fF
C895 a_1232_1368# Gnd 0.01fF
C896 a_1174_1352# Gnd 5.68fF
C897 a_2236_1379# Gnd 0.01fF
C898 a_2080_1400# Gnd 0.01fF
C899 a_530_1159# Gnd 21.30fF
C900 a_2402_1428# Gnd 0.01fF
C901 a_2181_1379# Gnd 0.70fF
C902 S3 Gnd 1.47fF
C903 a_808_1394# Gnd 0.01fF
C904 a_800_1394# Gnd 0.01fF
C905 a_446_1407# Gnd 0.01fF
C906 a_2236_1465# Gnd 0.01fF
C907 a_2025_1400# Gnd 1.30fF
C908 a_2181_1465# Gnd 0.78fF
C909 C2 Gnd 5.10fF
C910 a_438_1480# Gnd 0.01fF
C911 a_282_1501# Gnd 0.01fF
C912 a_382_1341# Gnd 2.53fF
C913 a_604_1529# Gnd 0.01fF
C914 a_383_1480# Gnd 0.70fF
C915 a_438_1566# Gnd 0.01fF
C916 a_227_1501# Gnd 1.30fF
C917 a_383_1566# Gnd 0.78fF
C918 A1 Gnd 0.06fF
C919 a_1061_1614# Gnd 0.01fF
C920 a_874_1613# Gnd 0.01fF
C921 a_806_1390# Gnd 1.72fF
C922 a_1061_1622# Gnd 0.01fF
C923 a_814_1390# Gnd 1.41fF
C924 a_2295_1698# Gnd 0.01fF
C925 a_698_1711# Gnd 13.81fF
C926 a_2139_1719# Gnd 0.01fF
C927 a_549_1529# Gnd 23.45fF
C928 a_2461_1747# Gnd 0.01fF
C929 a_2240_1698# Gnd 0.70fF
C930 S2 Gnd 1.09fF
C931 a_878_1761# Gnd 0.01fF
C932 a_705_1760# Gnd 0.01fF
C933 a_647_1760# Gnd 1.09fF
C934 a_2295_1784# Gnd 0.01fF
C935 a_2084_1719# Gnd 1.30fF
C936 a_1043_1782# Gnd 0.01fF
C937 a_800_1767# Gnd 3.27fF
C938 a_2240_1784# Gnd 0.78fF
C939 C1 Gnd 5.86fF
C940 a_847_1827# Gnd 0.01fF
C941 a_691_1848# Gnd 0.01fF
C942 B0 Gnd 0.06fF
C943 a_1013_1876# Gnd 0.01fF
C944 a_792_1827# Gnd 0.70fF
C945 a_847_1913# Gnd 0.01fF
C946 a_636_1848# Gnd 1.30fF
C947 a_2276_1927# Gnd 0.01fF
C948 a_792_1913# Gnd 0.78fF
C949 A0 Gnd 0.06fF
C950 a_2120_1948# Gnd 0.01fF
C951 cin Gnd 0.06fF
C952 a_2442_1976# Gnd 0.01fF
C953 a_2221_1927# Gnd 0.70fF
C954 S1 Gnd 1.13fF
C955 gnd Gnd 85.40fF
C956 a_2276_2013# Gnd 0.01fF
C957 a_2065_1948# Gnd 1.30fF
C958 a_2221_2013# Gnd 0.78fF
C959 a_958_1876# Gnd 23.10fF
C960 vdd Gnd 74.66fF
C961 w_1114_125# Gnd 2.92fF
C962 w_330_149# Gnd 1.67fF
C963 w_362_217# Gnd 1.67fF
C964 w_528_266# Gnd 1.67fF
C965 w_206_238# Gnd 1.67fF
C966 w_362_303# Gnd 1.67fF
C967 w_1440_382# Gnd 2.92fF
C968 w_1171_350# Gnd 2.51fF
C969 w_911_370# Gnd 2.09fF
C970 w_718_366# Gnd 1.67fF
C971 w_332_386# Gnd 1.25fF
C972 w_318_489# Gnd 1.67fF
C973 w_2120_587# Gnd 1.67fF
C974 w_2286_636# Gnd 1.67fF
C975 w_1964_608# Gnd 1.67fF
C976 w_2120_673# Gnd 1.67fF
C977 w_971_624# Gnd 2.51fF
C978 w_373_597# Gnd 1.67fF
C979 w_539_646# Gnd 1.67fF
C980 w_217_618# Gnd 1.67fF
C981 w_373_683# Gnd 1.67fF
C982 w_1161_844# Gnd 2.51fF
C983 w_945_840# Gnd 2.09fF
C984 w_743_830# Gnd 1.67fF
C985 w_380_831# Gnd 1.25fF
C986 w_2154_974# Gnd 1.67fF
C987 w_2320_1023# Gnd 1.67fF
C988 w_1998_995# Gnd 1.67fF
C989 w_2154_1060# Gnd 1.67fF
C990 w_1308_1038# Gnd 2.51fF
C991 w_326_1012# Gnd 1.67fF
C992 w_358_1097# Gnd 1.67fF
C993 w_524_1146# Gnd 1.67fF
C994 w_202_1118# Gnd 1.67fF
C995 w_358_1183# Gnd 1.67fF
C996 w_727_1294# Gnd 1.67fF
C997 w_2175_1366# Gnd 1.67fF
C998 w_1168_1339# Gnd 2.51fF
C999 w_916_1329# Gnd 2.09fF
C1000 w_392_1330# Gnd 1.25fF
C1001 w_2341_1415# Gnd 1.67fF
C1002 w_2019_1387# Gnd 1.67fF
C1003 w_382_1394# Gnd 1.67fF
C1004 w_2175_1452# Gnd 1.67fF
C1005 w_787_1466# Gnd 2.09fF
C1006 w_377_1467# Gnd 1.67fF
C1007 w_543_1516# Gnd 1.67fF
C1008 w_221_1488# Gnd 1.67fF
C1009 w_377_1553# Gnd 1.67fF
C1010 w_997_1601# Gnd 2.09fF
C1011 w_810_1600# Gnd 1.67fF
C1012 w_2234_1685# Gnd 1.67fF
C1013 w_2400_1734# Gnd 1.67fF
C1014 w_2078_1706# Gnd 1.67fF
C1015 w_692_1698# Gnd 1.25fF
C1016 w_2234_1771# Gnd 1.67fF
C1017 w_979_1769# Gnd 1.67fF
C1018 w_814_1748# Gnd 1.67fF
C1019 w_641_1747# Gnd 1.67fF
C1020 w_786_1814# Gnd 1.67fF
C1021 w_952_1863# Gnd 1.67fF
C1022 w_630_1835# Gnd 1.67fF
C1023 w_2215_1914# Gnd 1.67fF
C1024 w_786_1900# Gnd 1.67fF
C1025 w_2381_1963# Gnd 1.67fF
C1026 w_2059_1935# Gnd 1.67fF
C1027 w_2215_2000# Gnd 1.67fF

Vdd vdd gnd 1.8

Va0 a0 gnd 1.8
Va1 a1 gnd 1.8
Va2 a2 gnd 1.8
Va3 a3 gnd 1.8
Va4 a4 gnd 1.8

Vb0 b0 gnd PULSE(0 1.8 20n 0 0 5n 10n)
Vb1 b1 gnd 0
Vb2 b2 gnd 0
Vb3 b3 gnd 0
Vb4 b4 gnd 0
Vcin cin gnd 0

.control
tran 0.1n 50n
*plot v(a0) v(a1)+2 v(a2)+4 v(a3)+6 v(a4)+8
plot v(b0)
*v(b1)+2 v(b2)+4 v(b3)+6 v(b4)+8
plot v(S1) v(S2)+2 v(S3)+4 v(S4)+6 v(S5)+8
plot v(c5)

* Propagation delay: t(50% of cout) - t(50% of b0)
meas tran t_b0_50_rise  WHEN v(b0)=0.9 RISE=1
meas tran t_cout_50_rise  WHEN v(c5)=0.9 RISE=1
print (-t_b0_50_rise+t_cout_50_rise)
meas tran t_b0_50_fall  WHEN v(b0)=0.9 FALL=1
meas tran t_cout_50_fall  WHEN v(c5)=0.9 FALL=1
print (-t_b0_50_fall+t_cout_50_fall)
run

 t_b0_50_rise        =  2.005000e-08
 t_cout_50_rise      =  2.065100e-08
 t_b0_50_fall        =  2.515000e-08
 t_cout_50_fall      =  2.575381e-08
 Propagation delay results:
 Rise delay  = t_cout_50_rise - t_b0_50_rise = 601.00 psec
 Fall delay  = t_cout_50_fall - t_b0_50_fall = 603.81 psec

 .endc
.end
