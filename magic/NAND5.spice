* SPICE3 file created from NAND5.ext - technology: scmos

.option scale=0.09u

M1000 out E vdd w_0_102# pfet w=40 l=2
+  ad=680 pd=274 as=680 ps=274
M1001 a_37_n10# D a_29_n10# Gnd nfet w=100 l=2
+  ad=600 pd=212 as=600 ps=212
M1002 a_21_n10# B a_13_n10# Gnd nfet w=100 l=2
+  ad=600 pd=212 as=600 ps=212
M1003 vdd B out w_0_102# pfet w=40 l=2
+  ad=0 pd=0 as=0 ps=0
M1004 out A vdd w_0_102# pfet w=40 l=2
+  ad=0 pd=0 as=0 ps=0
M1005 gnd E a_37_n10# Gnd nfet w=100 l=2
+  ad=600 pd=212 as=0 ps=0
M1006 out C vdd w_0_102# pfet w=40 l=2
+  ad=0 pd=0 as=0 ps=0
M1007 a_29_n10# C a_21_n10# Gnd nfet w=100 l=2
+  ad=0 pd=0 as=0 ps=0
M1008 vdd D out w_0_102# pfet w=40 l=2
+  ad=0 pd=0 as=0 ps=0
M1009 a_13_n10# A out Gnd nfet w=100 l=2
+  ad=0 pd=0 as=500 ps=210
C0 out a_21_n10# 0.03fF
C1 out E 0.08fF
C2 out D 0.08fF
C3 E D 0.21fF
C4 gnd a_37_n10# 0.86fF
C5 B vdd 0.10fF
C6 w_0_102# B 0.08fF
C7 B C 0.21fF
C8 A B 0.21fF
C9 w_0_102# vdd 0.14fF
C10 out a_13_n10# 1.06fF
C11 C vdd 0.10fF
C12 w_0_102# C 0.08fF
C13 gnd a_29_n10# 0.03fF
C14 A vdd 0.10fF
C15 w_0_102# A 0.08fF
C16 a_21_n10# a_13_n10# 1.03fF
C17 gnd out 0.05fF
C18 B out 0.08fF
C19 a_37_n10# a_29_n10# 1.03fF
C20 gnd a_21_n10# 0.03fF
C21 out vdd 2.13fF
C22 a_37_n10# out 0.03fF
C23 w_0_102# out 0.11fF
C24 C out 0.08fF
C25 A out 0.08fF
C26 vdd E 0.10fF
C27 vdd D 0.10fF
C28 w_0_102# E 0.08fF
C29 w_0_102# D 0.08fF
C30 C D 0.21fF
C31 out a_29_n10# 0.03fF
C32 gnd a_13_n10# 0.03fF
C33 a_21_n10# a_29_n10# 1.03fF
C34 gnd Gnd 0.29fF
C35 a_37_n10# Gnd 0.01fF
C36 a_29_n10# Gnd 0.01fF
C37 a_21_n10# Gnd 0.01fF
C38 a_13_n10# Gnd 0.01fF
C39 out Gnd 0.25fF
C40 vdd Gnd 0.09fF
C41 E Gnd 0.22fF
C42 D Gnd 0.22fF
C43 C Gnd 0.22fF
C44 B Gnd 0.22fF
C45 A Gnd 0.22fF
C46 w_0_102# Gnd 2.92fF
